; generated by gen_skill.py -- ECE 555 MS1 neuron cells
nLib = "NEURON"
nLog = outfile("/userspace/apyadav/ece555/ms1/build.txt")
unless(ddGetObj(nLib)
  let((l) l = ddCreateLib(nLib "/userspace/apyadav/ece555/NEURON")
    techBindTechFile(l "asap7_TechLib")
    fprintf(nLog "created lib %L\n" l)))

procedure(nPinCenter(inst term)
  let((tm bb c)
    tm = car(setof(x inst~>master~>terminals x~>name == term))
    bb = car(tm~>pins)~>fig~>bBox
    c = list((xCoord(car(bb)) + xCoord(cadr(bb))) / 2.0
             (yCoord(car(bb)) + yCoord(cadr(bb))) / 2.0)
    dbTransformPoint(c inst~>transform)))
procedure(nWire(cv pts) car(schCreateWire(cv "draw" "full" pts 0.0625 0.0625 0.0)))
procedure(nLabel(cv wr xy name just)
  schCreateWireLabel(cv wr xy name just "R0" "stick" 0.0625 nil))
procedure(nStub(cv inst term dx dy name)
  let((p q just)
    p = nPinCenter(inst term)
    q = list(xCoord(p) + dx yCoord(p) + dy)
    just = cond((dx < 0 "lowerRight") (dx > 0 "lowerLeft") (t "lowerCenter"))
    nLabel(cv nWire(cv list(p q)) q name just)))
; stub pointing away from the symbol body (pin on bbox edge decides direction)
procedure(nStubAuto(cv inst term len name)
  let((p bb dx dy)
    p = nPinCenter(inst term)
    bb = inst~>master~>bBox
    bb = list(dbTransformPoint(car(bb) inst~>transform) dbTransformPoint(cadr(bb) inst~>transform))
    dx = 0 dy = 0
    cond(
      (abs(xCoord(p) - min(xCoord(car(bb)) xCoord(cadr(bb)))) < 0.03 dx = -len)
      (abs(xCoord(p) - max(xCoord(car(bb)) xCoord(cadr(bb)))) < 0.03 dx = len)
      (abs(yCoord(p) - max(yCoord(car(bb)) yCoord(cadr(bb)))) < 0.03 dy = len)
      (t dy = -len))
    nStub(cv inst term dx dy name)))
procedure(nMos(cv typ name xy nfin)
  let((m inst)
    m = dbOpenCellViewByType("asap7_TechLib" if(typ == "p" "pmos_rvt" "nmos_rvt") "symbol")
    inst = schCreateInst(cv m name xy "R0")
    dbReplaceProp(inst "nfin" "int" nfin)
    dbReplaceProp(inst "w" "string" sprintf(nil "%dn" 27*nfin))
    dbReplaceProp(inst "l" "string" "20n")
    inst))
procedure(nPin(cv name dir xy)
  let((m pin p q)
    m = dbOpenCellViewByType("basic" case(dir ("input" "ipin") ("output" "opin") (t "iopin")) "symbol")
    pin = schCreatePin(cv m name dir nil xy "R0")
    p = nPinCenter(pin car(pin~>master~>terminals)~>name)
    q = list(xCoord(p) + if(dir == "output" -0.5 0.5) yCoord(p))
    nLabel(cv nWire(cv list(p q)) q name if(dir == "output" "lowerRight" "lowerLeft"))
    pin))
; terminals of a mos symbol: D/S direction from pin position vs origin
procedure(nMosStubs(cv inst d g s b)
  let((pd ps o)
    o = inst~>xy
    pd = nPinCenter(inst "D") ps = nPinCenter(inst "S")
    nStub(cv inst "D" 0 if(yCoord(pd) > yCoord(o) 0.25 -0.25) d)
    nStub(cv inst "S" 0 if(yCoord(ps) > yCoord(o) 0.25 -0.25) s)
    nStub(cv inst "G" -0.375 0 g)
    nStub(cv inst "B" 0.875 0 b)))
procedure(nDump(cv)
  fprintf(nLog "CELL %s\n" cv~>cellName)
  foreach(i cv~>instances
    unless(i~>purpose == "pin"
      fprintf(nLog "  I %s %s %L %L\n" i~>name i~>cellName i~>nfin
        sort(mapcar(lambda((it) strcat(it~>term~>name "=" it~>net~>name)) i~>instTerms) 'alphalessp))))
  fprintf(nLog "  TERMS %L\n" sort(cv~>terminals~>name 'alphalessp)))
procedure(nSymPin(cv name dir xy lead labXY labJust)
  let((x y fig net term)
    x = xCoord(xy) y = yCoord(xy)
    dbCreateLine(cv list("device" "drawing") list(xy lead))
    fig = dbCreateRect(cv list("pin" "drawing") list(list(x - 0.025 y - 0.025) list(x + 0.025 y + 0.025)))
    net = dbCreateNet(cv name)
    term = dbCreateTerm(net name dir)
    dbCreatePin(net fig name)
    when(labXY dbCreateLabel(cv list("pin" "drawing") labXY name labJust "R0" "stick" 0.045))
    term))
procedure(nSymFinish(cv bb)
  let((lb)
    dbCreateRect(cv list("instance" "drawing") bb)
    lb = dbCreateLabel(cv list("annotate" "drawing7") list(xCoord(car(bb)) yCoord(cadr(bb)) + 0.03)
                       "[@instanceName]" "lowerLeft" "R0" "stick" 0.05)
    lb~>labelType = "NLPLabel"
    dbReplaceProp(cv "interfaceLastChanged" "time" getCurrentTime())
    dbSave(cv) dbClose(cv)))

errset(progn(
  ; ---- INV
  cv = dbOpenCellViewByType(nLib "INV" "schematic" "schematic" "w")
    nMosStubs(cv nMos(cv "p" "MP0" 0.0000:1.5000 3) "Y" "A" "VDD" "VDD")
    nMosStubs(cv nMos(cv "n" "MN0" 0.0000:0.0000 2) "Y" "A" "VSS" "VSS")
    nPin(cv "A" "input" -2.5000:2.2500)
    nPin(cv "VDD" "inputOutput" -2.5000:1.7500)
    nPin(cv "VSS" "inputOutput" -2.5000:1.2500)
    nPin(cv "Y" "output" 2.5000:1.5000)
    schCheck(cv) dbSave(cv)
    fprintf(nLog "%s check markers=%L\n" cv~>cellName length(setof(s cv~>shapes s~>objType == "marker")))
    nDump(cv) dbClose(cv)
  cv = dbOpenCellViewByType(nLib "INV" "symbol" "schematicSymbol" "w")
    dbCreateLine(cv list("device" "drawing") list(0.2500:0.3750 0.9000:0.0000 0.2500:-0.3750 0.2500:0.3750))
    dbCreateLine(cv list("device" "drawing") list(1.0000:0.0000 0.9962:0.0191 0.9854:0.0354 0.9691:0.0462 0.9500:0.0500 0.9309:0.0462 0.9146:0.0354 0.9038:0.0191 0.9000:0.0000 0.9038:-0.0191 0.9146:-0.0354 0.9309:-0.0462 0.9500:-0.0500 0.9691:-0.0462 0.9854:-0.0354 0.9962:-0.0191 1.0000:-0.0000))
    nSymPin(cv "A" "input" 0.0000:0.0000 0.2500:0.0000 nil nil)
    nSymPin(cv "Y" "output" 1.2500:0.0000 1.0000:0.0000 nil nil)
    nSymPin(cv "VDD" "inputOutput" 0.5000:0.6250 0.5000:0.7308 nil nil)
    nSymPin(cv "VSS" "inputOutput" 0.5000:-0.6250 0.5000:-0.2308 nil nil)
    dbCreateLabel(cv list("annotate" "drawing8") 0.5000:-0.7250 "[@cellName]" "upperCenter" "R0" "stick" 0.045)~>labelType = "NLPLabel"
    nSymFinish(cv list(0.0000:-0.6250 1.2500:0.6250))
  ; ---- NAND2
  cv = dbOpenCellViewByType(nLib "NAND2" "schematic" "schematic" "w")
    nMosStubs(cv nMos(cv "p" "MP0" 0.0000:1.5000 3) "Y" "A" "VDD" "VDD")
    nMosStubs(cv nMos(cv "p" "MP1" 2.0000:1.5000 3) "Y" "B" "VDD" "VDD")
    nMosStubs(cv nMos(cv "n" "MN0" 0.0000:0.0000 2) "Y" "A" "n1" "VSS")
    nMosStubs(cv nMos(cv "n" "MN1" 2.0000:0.0000 2) "n1" "B" "VSS" "VSS")
    nPin(cv "A" "input" -2.5000:2.5000)
    nPin(cv "B" "input" -2.5000:2.0000)
    nPin(cv "VDD" "inputOutput" -2.5000:1.5000)
    nPin(cv "VSS" "inputOutput" -2.5000:1.0000)
    nPin(cv "Y" "output" 4.5000:1.5000)
    schCheck(cv) dbSave(cv)
    fprintf(nLog "%s check markers=%L\n" cv~>cellName length(setof(s cv~>shapes s~>objType == "marker")))
    nDump(cv) dbClose(cv)
  cv = dbOpenCellViewByType(nLib "NAND2" "symbol" "schematicSymbol" "w")
    dbCreateLine(cv list("device" "drawing") list(0.6000:0.3750 0.2500:0.3750 0.2500:-0.3750 0.6000:-0.3750))
    dbCreateLine(cv list("device" "drawing") list(0.6000:0.3750 0.6732:0.3678 0.7435:0.3465 0.8083:0.3118 0.8652:0.2652 0.9118:0.2083 0.9465:0.1435 0.9678:0.0732 0.9750:0.0000 0.9678:-0.0732 0.9465:-0.1435 0.9118:-0.2083 0.8652:-0.2652 0.8083:-0.3118 0.7435:-0.3465 0.6732:-0.3678 0.6000:-0.3750))
    dbCreateLine(cv list("device" "drawing") list(1.0750:0.0000 1.0712:0.0191 1.0604:0.0354 1.0441:0.0462 1.0250:0.0500 1.0059:0.0462 0.9896:0.0354 0.9788:0.0191 0.9750:0.0000 0.9788:-0.0191 0.9896:-0.0354 1.0059:-0.0462 1.0250:-0.0500 1.0441:-0.0462 1.0604:-0.0354 1.0712:-0.0191 1.0750:-0.0000))
    nSymPin(cv "A" "input" 0.0000:0.1250 0.2500:0.1250 nil nil)
    nSymPin(cv "B" "input" 0.0000:-0.1250 0.2500:-0.1250 nil nil)
    nSymPin(cv "Y" "output" 1.3750:0.0000 1.0750:0.0000 nil nil)
    nSymPin(cv "VDD" "inputOutput" 0.5000:0.6250 0.5000:0.3750 nil nil)
    nSymPin(cv "VSS" "inputOutput" 0.5000:-0.6250 0.5000:-0.3750 nil nil)
    dbCreateLabel(cv list("annotate" "drawing8") 0.5000:-0.7250 "[@cellName]" "upperCenter" "R0" "stick" 0.045)~>labelType = "NLPLabel"
    nSymFinish(cv list(0.0000:-0.6250 1.3750:0.6250))
  ; ---- NOR2
  cv = dbOpenCellViewByType(nLib "NOR2" "schematic" "schematic" "w")
    nMosStubs(cv nMos(cv "p" "MP0" 0.0000:1.5000 3) "p1" "A" "VDD" "VDD")
    nMosStubs(cv nMos(cv "p" "MP1" 2.0000:1.5000 3) "Y" "B" "p1" "VDD")
    nMosStubs(cv nMos(cv "n" "MN0" 0.0000:0.0000 2) "Y" "A" "VSS" "VSS")
    nMosStubs(cv nMos(cv "n" "MN1" 2.0000:0.0000 2) "Y" "B" "VSS" "VSS")
    nPin(cv "A" "input" -2.5000:2.5000)
    nPin(cv "B" "input" -2.5000:2.0000)
    nPin(cv "VDD" "inputOutput" -2.5000:1.5000)
    nPin(cv "VSS" "inputOutput" -2.5000:1.0000)
    nPin(cv "Y" "output" 4.5000:1.5000)
    schCheck(cv) dbSave(cv)
    fprintf(nLog "%s check markers=%L\n" cv~>cellName length(setof(s cv~>shapes s~>objType == "marker")))
    nDump(cv) dbClose(cv)
  cv = dbOpenCellViewByType(nLib "NOR2" "symbol" "schematicSymbol" "w")
    dbCreateLine(cv list("device" "drawing") list(0.2500:0.3750 0.2806:0.3125 0.3056:0.2500 0.3250:0.1875 0.3389:0.1250 0.3472:0.0625 0.3500:0.0000 0.3472:-0.0625 0.3389:-0.1250 0.3250:-0.1875 0.3056:-0.2500 0.2806:-0.3125 0.2500:-0.3750))
    dbCreateLine(cv list("device" "drawing") list(0.2500:0.3750 0.3316:0.3724 0.4097:0.3646 0.4844:0.3516 0.5556:0.3333 0.6233:0.3099 0.6875:0.2812 0.7483:0.2474 0.8056:0.2083 0.8594:0.1641 0.9097:0.1146 0.9566:0.0599 1.0000:0.0000))
    dbCreateLine(cv list("device" "drawing") list(0.2500:-0.3750 0.3316:-0.3724 0.4097:-0.3646 0.4844:-0.3516 0.5556:-0.3333 0.6233:-0.3099 0.6875:-0.2812 0.7483:-0.2474 0.8056:-0.2083 0.8594:-0.1641 0.9097:-0.1146 0.9566:-0.0599 1.0000:0.0000))
    dbCreateLine(cv list("device" "drawing") list(1.1000:0.0000 1.0962:0.0191 1.0854:0.0354 1.0691:0.0462 1.0500:0.0500 1.0309:0.0462 1.0146:0.0354 1.0038:0.0191 1.0000:0.0000 1.0038:-0.0191 1.0146:-0.0354 1.0309:-0.0462 1.0500:-0.0500 1.0691:-0.0462 1.0854:-0.0354 1.0962:-0.0191 1.1000:-0.0000))
    nSymPin(cv "A" "input" 0.0000:0.1250 0.3389:0.1250 nil nil)
    nSymPin(cv "B" "input" 0.0000:-0.1250 0.3389:-0.1250 nil nil)
    nSymPin(cv "Y" "output" 1.3750:0.0000 1.1000:0.0000 nil nil)
    nSymPin(cv "VDD" "inputOutput" 0.5000:0.6250 0.5000:0.3750 nil nil)
    nSymPin(cv "VSS" "inputOutput" 0.5000:-0.6250 0.5000:-0.3750 nil nil)
    dbCreateLabel(cv list("annotate" "drawing8") 0.5000:-0.7250 "[@cellName]" "upperCenter" "R0" "stick" 0.045)~>labelType = "NLPLabel"
    nSymFinish(cv list(0.0000:-0.6250 1.3750:0.6250))
  ; ---- NOR3
  cv = dbOpenCellViewByType(nLib "NOR3" "schematic" "schematic" "w")
    nMosStubs(cv nMos(cv "p" "MP0" 0.0000:1.5000 3) "p1" "A" "VDD" "VDD")
    nMosStubs(cv nMos(cv "p" "MP1" 2.0000:1.5000 3) "p2" "B" "p1" "VDD")
    nMosStubs(cv nMos(cv "p" "MP2" 4.0000:1.5000 3) "Y" "C" "p2" "VDD")
    nMosStubs(cv nMos(cv "n" "MN0" 0.0000:0.0000 2) "Y" "A" "VSS" "VSS")
    nMosStubs(cv nMos(cv "n" "MN1" 2.0000:0.0000 2) "Y" "B" "VSS" "VSS")
    nMosStubs(cv nMos(cv "n" "MN2" 4.0000:0.0000 2) "Y" "C" "VSS" "VSS")
    nPin(cv "A" "input" -2.5000:2.7500)
    nPin(cv "B" "input" -2.5000:2.2500)
    nPin(cv "C" "input" -2.5000:1.7500)
    nPin(cv "VDD" "inputOutput" -2.5000:1.2500)
    nPin(cv "VSS" "inputOutput" -2.5000:0.7500)
    nPin(cv "Y" "output" 6.5000:1.5000)
    schCheck(cv) dbSave(cv)
    fprintf(nLog "%s check markers=%L\n" cv~>cellName length(setof(s cv~>shapes s~>objType == "marker")))
    nDump(cv) dbClose(cv)
  cv = dbOpenCellViewByType(nLib "NOR3" "symbol" "schematicSymbol" "w")
    dbCreateLine(cv list("device" "drawing") list(0.2500:0.3750 0.2806:0.3125 0.3056:0.2500 0.3250:0.1875 0.3389:0.1250 0.3472:0.0625 0.3500:0.0000 0.3472:-0.0625 0.3389:-0.1250 0.3250:-0.1875 0.3056:-0.2500 0.2806:-0.3125 0.2500:-0.3750))
    dbCreateLine(cv list("device" "drawing") list(0.2500:0.3750 0.3316:0.3724 0.4097:0.3646 0.4844:0.3516 0.5556:0.3333 0.6233:0.3099 0.6875:0.2812 0.7483:0.2474 0.8056:0.2083 0.8594:0.1641 0.9097:0.1146 0.9566:0.0599 1.0000:0.0000))
    dbCreateLine(cv list("device" "drawing") list(0.2500:-0.3750 0.3316:-0.3724 0.4097:-0.3646 0.4844:-0.3516 0.5556:-0.3333 0.6233:-0.3099 0.6875:-0.2812 0.7483:-0.2474 0.8056:-0.2083 0.8594:-0.1641 0.9097:-0.1146 0.9566:-0.0599 1.0000:0.0000))
    dbCreateLine(cv list("device" "drawing") list(1.1000:0.0000 1.0962:0.0191 1.0854:0.0354 1.0691:0.0462 1.0500:0.0500 1.0309:0.0462 1.0146:0.0354 1.0038:0.0191 1.0000:0.0000 1.0038:-0.0191 1.0146:-0.0354 1.0309:-0.0462 1.0500:-0.0500 1.0691:-0.0462 1.0854:-0.0354 1.0962:-0.0191 1.1000:-0.0000))
    nSymPin(cv "A" "input" 0.0000:0.2500 0.3056:0.2500 nil nil)
    nSymPin(cv "B" "input" 0.0000:0.0000 0.3500:0.0000 nil nil)
    nSymPin(cv "C" "input" 0.0000:-0.2500 0.3056:-0.2500 nil nil)
    nSymPin(cv "Y" "output" 1.3750:0.0000 1.1000:0.0000 nil nil)
    nSymPin(cv "VDD" "inputOutput" 0.5000:0.6250 0.5000:0.3750 nil nil)
    nSymPin(cv "VSS" "inputOutput" 0.5000:-0.6250 0.5000:-0.3750 nil nil)
    dbCreateLabel(cv list("annotate" "drawing8") 0.5000:-0.7250 "[@cellName]" "upperCenter" "R0" "stick" 0.045)~>labelType = "NLPLabel"
    nSymFinish(cv list(0.0000:-0.6250 1.3750:0.6250))
  ; ---- XNOR2
  cv = dbOpenCellViewByType(nLib "XNOR2" "schematic" "schematic" "w")
    nMosStubs(cv nMos(cv "p" "MP4" 0.0000:1.5000 3) "AN" "A" "VDD" "VDD")
    nMosStubs(cv nMos(cv "p" "MP5" 2.0000:1.5000 3) "BN" "B" "VDD" "VDD")
    nMosStubs(cv nMos(cv "p" "MP0" 4.0000:1.5000 3) "p1" "A" "VDD" "VDD")
    nMosStubs(cv nMos(cv "p" "MP1" 6.0000:1.5000 3) "p1" "BN" "VDD" "VDD")
    nMosStubs(cv nMos(cv "p" "MP2" 8.0000:1.5000 3) "Y" "AN" "p1" "VDD")
    nMosStubs(cv nMos(cv "p" "MP3" 10.0000:1.5000 3) "Y" "B" "p1" "VDD")
    nMosStubs(cv nMos(cv "n" "MN4" 0.0000:0.0000 2) "AN" "A" "VSS" "VSS")
    nMosStubs(cv nMos(cv "n" "MN5" 2.0000:0.0000 2) "BN" "B" "VSS" "VSS")
    nMosStubs(cv nMos(cv "n" "MN0" 4.0000:0.0000 2) "Y" "A" "n1" "VSS")
    nMosStubs(cv nMos(cv "n" "MN1" 6.0000:0.0000 2) "n1" "BN" "VSS" "VSS")
    nMosStubs(cv nMos(cv "n" "MN2" 8.0000:0.0000 2) "Y" "AN" "n2" "VSS")
    nMosStubs(cv nMos(cv "n" "MN3" 10.0000:0.0000 2) "n2" "B" "VSS" "VSS")
    nPin(cv "A" "input" -2.5000:2.5000)
    nPin(cv "B" "input" -2.5000:2.0000)
    nPin(cv "VDD" "inputOutput" -2.5000:1.5000)
    nPin(cv "VSS" "inputOutput" -2.5000:1.0000)
    nPin(cv "Y" "output" 12.5000:1.5000)
    schCheck(cv) dbSave(cv)
    fprintf(nLog "%s check markers=%L\n" cv~>cellName length(setof(s cv~>shapes s~>objType == "marker")))
    nDump(cv) dbClose(cv)
  cv = dbOpenCellViewByType(nLib "XNOR2" "symbol" "schematicSymbol" "w")
    dbCreateLine(cv list("device" "drawing") list(0.2500:0.3750 0.2806:0.3125 0.3056:0.2500 0.3250:0.1875 0.3389:0.1250 0.3472:0.0625 0.3500:0.0000 0.3472:-0.0625 0.3389:-0.1250 0.3250:-0.1875 0.3056:-0.2500 0.2806:-0.3125 0.2500:-0.3750))
    dbCreateLine(cv list("device" "drawing") list(0.2500:0.3750 0.3316:0.3724 0.4097:0.3646 0.4844:0.3516 0.5556:0.3333 0.6233:0.3099 0.6875:0.2812 0.7483:0.2474 0.8056:0.2083 0.8594:0.1641 0.9097:0.1146 0.9566:0.0599 1.0000:0.0000))
    dbCreateLine(cv list("device" "drawing") list(0.2500:-0.3750 0.3316:-0.3724 0.4097:-0.3646 0.4844:-0.3516 0.5556:-0.3333 0.6233:-0.3099 0.6875:-0.2812 0.7483:-0.2474 0.8056:-0.2083 0.8594:-0.1641 0.9097:-0.1146 0.9566:-0.0599 1.0000:0.0000))
    dbCreateLine(cv list("device" "drawing") list(0.1700:0.3750 0.2006:0.3125 0.2256:0.2500 0.2450:0.1875 0.2589:0.1250 0.2672:0.0625 0.2700:0.0000 0.2672:-0.0625 0.2589:-0.1250 0.2450:-0.1875 0.2256:-0.2500 0.2006:-0.3125 0.1700:-0.3750))
    dbCreateLine(cv list("device" "drawing") list(1.1000:0.0000 1.0962:0.0191 1.0854:0.0354 1.0691:0.0462 1.0500:0.0500 1.0309:0.0462 1.0146:0.0354 1.0038:0.0191 1.0000:0.0000 1.0038:-0.0191 1.0146:-0.0354 1.0309:-0.0462 1.0500:-0.0500 1.0691:-0.0462 1.0854:-0.0354 1.0962:-0.0191 1.1000:-0.0000))
    nSymPin(cv "A" "input" 0.0000:0.1250 0.2589:0.1250 nil nil)
    nSymPin(cv "B" "input" 0.0000:-0.1250 0.2589:-0.1250 nil nil)
    nSymPin(cv "Y" "output" 1.3750:0.0000 1.1000:0.0000 nil nil)
    nSymPin(cv "VDD" "inputOutput" 0.5000:0.6250 0.5000:0.3750 nil nil)
    nSymPin(cv "VSS" "inputOutput" 0.5000:-0.6250 0.5000:-0.3750 nil nil)
    dbCreateLabel(cv list("annotate" "drawing8") 0.5000:-0.7250 "[@cellName]" "upperCenter" "R0" "stick" 0.045)~>labelType = "NLPLabel"
    nSymFinish(cv list(0.0000:-0.6250 1.3750:0.6250))
  ; ---- AOI211
  cv = dbOpenCellViewByType(nLib "AOI211" "schematic" "schematic" "w")
    nMosStubs(cv nMos(cv "p" "MP0" 0.0000:1.5000 3) "p1" "C" "VDD" "VDD")
    nMosStubs(cv nMos(cv "p" "MP1" 2.0000:1.5000 3) "p2" "D" "p1" "VDD")
    nMosStubs(cv nMos(cv "p" "MP2" 4.0000:1.5000 3) "Y" "A" "p2" "VDD")
    nMosStubs(cv nMos(cv "p" "MP3" 6.0000:1.5000 3) "Y" "B" "p2" "VDD")
    nMosStubs(cv nMos(cv "n" "MN0" 0.0000:0.0000 2) "Y" "A" "n1" "VSS")
    nMosStubs(cv nMos(cv "n" "MN1" 2.0000:0.0000 2) "n1" "B" "VSS" "VSS")
    nMosStubs(cv nMos(cv "n" "MN2" 4.0000:0.0000 2) "Y" "C" "VSS" "VSS")
    nMosStubs(cv nMos(cv "n" "MN3" 6.0000:0.0000 2) "Y" "D" "VSS" "VSS")
    nPin(cv "A" "input" -2.5000:3.0000)
    nPin(cv "B" "input" -2.5000:2.5000)
    nPin(cv "C" "input" -2.5000:2.0000)
    nPin(cv "D" "input" -2.5000:1.5000)
    nPin(cv "VDD" "inputOutput" -2.5000:1.0000)
    nPin(cv "VSS" "inputOutput" -2.5000:0.5000)
    nPin(cv "Y" "output" 8.5000:1.5000)
    schCheck(cv) dbSave(cv)
    fprintf(nLog "%s check markers=%L\n" cv~>cellName length(setof(s cv~>shapes s~>objType == "marker")))
    nDump(cv) dbClose(cv)
  cv = dbOpenCellViewByType(nLib "AOI211" "symbol" "schematicSymbol" "w")
    dbCreateLine(cv list("device" "drawing") list(0.2500:0.6250 1.2500:0.6250 1.2500:-0.6250 0.2500:-0.6250 0.2500:0.6250))
    dbCreateLabel(cv list("device" "label") 0.7500:0.5650 "AOI211" "upperCenter" "R0" "stick" 0.06)
    nSymPin(cv "A" "input" 0.0000:0.3750 0.2500:0.3750 0.2800:0.3750 "centerLeft")
    nSymPin(cv "B" "input" 0.0000:0.1250 0.2500:0.1250 0.2800:0.1250 "centerLeft")
    nSymPin(cv "C" "input" 0.0000:-0.1250 0.2500:-0.1250 0.2800:-0.1250 "centerLeft")
    nSymPin(cv "D" "input" 0.0000:-0.3750 0.2500:-0.3750 0.2800:-0.3750 "centerLeft")
    nSymPin(cv "Y" "output" 1.5000:0.3750 1.2500:0.3750 1.2200:0.3750 "centerRight")
    nSymPin(cv "VDD" "inputOutput" 0.7500:0.8750 0.7500:0.6250 nil nil)
    nSymPin(cv "VSS" "inputOutput" 0.7500:-0.8750 0.7500:-0.6250 nil nil)
    dbCreateLabel(cv list("annotate" "drawing8") 0.7500:-0.9750 "[@cellName]" "upperCenter" "R0" "stick" 0.045)~>labelType = "NLPLabel"
    nSymFinish(cv list(0.0000:-0.8750 1.5000:0.8750))
  ; ---- TIELO
  cv = dbOpenCellViewByType(nLib "TIELO" "schematic" "schematic" "w")
    nMosStubs(cv nMos(cv "p" "MP0" 0.0000:1.5000 3) "h" "h" "VDD" "VDD")
    nMosStubs(cv nMos(cv "n" "MN0" 0.0000:0.0000 2) "Y" "h" "VSS" "VSS")
    nPin(cv "VDD" "inputOutput" -2.5000:2.0000)
    nPin(cv "VSS" "inputOutput" -2.5000:1.5000)
    nPin(cv "Y" "output" 2.5000:1.5000)
    schCheck(cv) dbSave(cv)
    fprintf(nLog "%s check markers=%L\n" cv~>cellName length(setof(s cv~>shapes s~>objType == "marker")))
    nDump(cv) dbClose(cv)
  cv = dbOpenCellViewByType(nLib "TIELO" "symbol" "schematicSymbol" "w")
    dbCreateLine(cv list("device" "drawing") list(0.2500:0.2500 1.2500:0.2500 1.2500:-0.2500 0.2500:-0.2500 0.2500:0.2500))
    dbCreateLabel(cv list("device" "label") 0.7500:0.1900 "TIE0" "upperCenter" "R0" "stick" 0.06)
    nSymPin(cv "Y" "output" 1.5000:0.0000 1.2500:0.0000 1.2200:0.0000 "centerRight")
    nSymPin(cv "VDD" "inputOutput" 0.7500:0.5000 0.7500:0.2500 nil nil)
    nSymPin(cv "VSS" "inputOutput" 0.7500:-0.5000 0.7500:-0.2500 nil nil)
    dbCreateLabel(cv list("annotate" "drawing8") 0.7500:-0.6000 "[@cellName]" "upperCenter" "R0" "stick" 0.045)~>labelType = "NLPLabel"
    nSymFinish(cv list(0.0000:-0.5000 1.5000:0.5000))
  ; ---- FA_MIRROR
  cv = dbOpenCellViewByType(nLib "FA_MIRROR" "schematic" "schematic" "w")
    nMosStubs(cv nMos(cv "p" "MP0" 0.0000:4.5000 3) "h1" "A" "VDD" "VDD")
    nMosStubs(cv nMos(cv "p" "MP1" 2.0000:4.5000 3) "h1" "B" "VDD" "VDD")
    nMosStubs(cv nMos(cv "p" "MP2" 4.0000:4.5000 3) "CON" "C" "h1" "VDD")
    nMosStubs(cv nMos(cv "p" "MP3" 6.0000:4.5000 3) "CON" "B" "h2" "VDD")
    nMosStubs(cv nMos(cv "p" "MP4" 8.0000:4.5000 3) "h2" "A" "VDD" "VDD")
    nMosStubs(cv nMos(cv "p" "MP5" 10.0000:4.5000 3) "h3" "A" "VDD" "VDD")
    nMosStubs(cv nMos(cv "p" "MP6" 0.0000:3.0000 3) "h3" "B" "VDD" "VDD")
    nMosStubs(cv nMos(cv "p" "MP7" 2.0000:3.0000 3) "h3" "C" "VDD" "VDD")
    nMosStubs(cv nMos(cv "p" "MP8" 4.0000:3.0000 3) "SN" "CON" "h3" "VDD")
    nMosStubs(cv nMos(cv "p" "MP9" 6.0000:3.0000 3) "SN" "C" "h4" "VDD")
    nMosStubs(cv nMos(cv "p" "MP10" 8.0000:3.0000 3) "h4" "B" "h5" "VDD")
    nMosStubs(cv nMos(cv "p" "MP11" 10.0000:3.0000 3) "h5" "A" "VDD" "VDD")
    nMosStubs(cv nMos(cv "n" "MN0" 0.0000:1.5000 2) "g1" "A" "VSS" "VSS")
    nMosStubs(cv nMos(cv "n" "MN1" 2.0000:1.5000 2) "g1" "B" "VSS" "VSS")
    nMosStubs(cv nMos(cv "n" "MN2" 4.0000:1.5000 2) "CON" "C" "g1" "VSS")
    nMosStubs(cv nMos(cv "n" "MN3" 6.0000:1.5000 2) "CON" "B" "g2" "VSS")
    nMosStubs(cv nMos(cv "n" "MN4" 8.0000:1.5000 2) "g2" "A" "VSS" "VSS")
    nMosStubs(cv nMos(cv "n" "MN5" 10.0000:1.5000 2) "g3" "A" "VSS" "VSS")
    nMosStubs(cv nMos(cv "n" "MN6" 0.0000:0.0000 2) "g3" "B" "VSS" "VSS")
    nMosStubs(cv nMos(cv "n" "MN7" 2.0000:0.0000 2) "g3" "C" "VSS" "VSS")
    nMosStubs(cv nMos(cv "n" "MN8" 4.0000:0.0000 2) "SN" "CON" "g3" "VSS")
    nMosStubs(cv nMos(cv "n" "MN9" 6.0000:0.0000 2) "SN" "C" "g4" "VSS")
    nMosStubs(cv nMos(cv "n" "MN10" 8.0000:0.0000 2) "g4" "B" "g5" "VSS")
    nMosStubs(cv nMos(cv "n" "MN11" 10.0000:0.0000 2) "g5" "A" "VSS" "VSS")
    nPin(cv "A" "input" -2.5000:4.2500)
    nPin(cv "B" "input" -2.5000:3.7500)
    nPin(cv "C" "input" -2.5000:3.2500)
    nPin(cv "VDD" "inputOutput" -2.5000:2.7500)
    nPin(cv "VSS" "inputOutput" -2.5000:2.2500)
    nPin(cv "CON" "output" 12.5000:3.0000)
    nPin(cv "SN" "output" 12.5000:2.5000)
    schCheck(cv) dbSave(cv)
    fprintf(nLog "%s check markers=%L\n" cv~>cellName length(setof(s cv~>shapes s~>objType == "marker")))
    nDump(cv) dbClose(cv)
  cv = dbOpenCellViewByType(nLib "FA_MIRROR" "symbol" "schematicSymbol" "w")
    dbCreateLine(cv list("device" "drawing") list(0.2500:0.5000 1.5000:0.5000 1.5000:-0.5000 0.2500:-0.5000 0.2500:0.5000))
    dbCreateLabel(cv list("device" "label") 0.8750:0.4400 "FA (mirror)" "upperCenter" "R0" "stick" 0.06)
    nSymPin(cv "A" "input" 0.0000:0.2500 0.2500:0.2500 0.2800:0.2500 "centerLeft")
    nSymPin(cv "B" "input" 0.0000:0.0000 0.2500:0.0000 0.2800:0.0000 "centerLeft")
    nSymPin(cv "C" "input" 0.0000:-0.2500 0.2500:-0.2500 0.2800:-0.2500 "centerLeft")
    nSymPin(cv "CON" "output" 1.7500:0.2500 1.5000:0.2500 1.4700:0.2500 "centerRight")
    nSymPin(cv "SN" "output" 1.7500:0.0000 1.5000:0.0000 1.4700:0.0000 "centerRight")
    nSymPin(cv "VDD" "inputOutput" 0.8750:0.7500 0.8750:0.5000 nil nil)
    nSymPin(cv "VSS" "inputOutput" 0.8750:-0.7500 0.8750:-0.5000 nil nil)
    dbCreateLabel(cv list("annotate" "drawing8") 0.8750:-0.8500 "[@cellName]" "upperCenter" "R0" "stick" 0.045)~>labelType = "NLPLabel"
    nSymFinish(cv list(0.0000:-0.7500 1.7500:0.7500))
  ; ---- MULT2
  cv = dbOpenCellViewByType(nLib "MULT2" "schematic" "schematic" "w")
    x = 0.0
    x = 0.0
    inst = schCreateInst(cv dbOpenCellViewByType(nLib "NAND2" "symbol") "I0" list(x 0.0) "R0")
    nStubAuto(cv inst "A" 0.375 "A0")
    nStubAuto(cv inst "B" 0.375 "B0")
    nStubAuto(cv inst "Y" 0.375 "n0")
    nStubAuto(cv inst "VDD" 0.375 "VDD")
    nStubAuto(cv inst "VSS" 0.375 "VSS")
    x = x + (xCoord(cadr(inst~>master~>bBox)) - xCoord(car(inst~>master~>bBox))) + 2.25
    inst = schCreateInst(cv dbOpenCellViewByType(nLib "INV" "symbol") "I1" list(x 0.0) "R0")
    nStubAuto(cv inst "A" 0.375 "n0")
    nStubAuto(cv inst "Y" 0.375 "P0")
    nStubAuto(cv inst "VDD" 0.375 "VDD")
    nStubAuto(cv inst "VSS" 0.375 "VSS")
    x = x + (xCoord(cadr(inst~>master~>bBox)) - xCoord(car(inst~>master~>bBox))) + 2.25
    x = 0.0
    inst = schCreateInst(cv dbOpenCellViewByType(nLib "XNOR2" "symbol") "I2" list(x -2.5) "R0")
    nStubAuto(cv inst "A" 0.375 "A1")
    nStubAuto(cv inst "B" 0.375 "B1")
    nStubAuto(cv inst "Y" 0.375 "xn")
    nStubAuto(cv inst "VDD" 0.375 "VDD")
    nStubAuto(cv inst "VSS" 0.375 "VSS")
    x = x + (xCoord(cadr(inst~>master~>bBox)) - xCoord(car(inst~>master~>bBox))) + 2.25
    inst = schCreateInst(cv dbOpenCellViewByType(nLib "NOR2" "symbol") "I3" list(x -2.5) "R0")
    nStubAuto(cv inst "A" 0.375 "n0")
    nStubAuto(cv inst "B" 0.375 "xn")
    nStubAuto(cv inst "Y" 0.375 "P1")
    nStubAuto(cv inst "VDD" 0.375 "VDD")
    nStubAuto(cv inst "VSS" 0.375 "VSS")
    x = x + (xCoord(cadr(inst~>master~>bBox)) - xCoord(car(inst~>master~>bBox))) + 2.25
    nPin(cv "A1" "input" -3.0000:1.0000)
    nPin(cv "A0" "input" -3.0000:0.6250)
    nPin(cv "B1" "input" -3.0000:0.2500)
    nPin(cv "B0" "input" -3.0000:-0.1250)
    nPin(cv "VDD" "inputOutput" -3.0000:-0.5000)
    nPin(cv "VSS" "inputOutput" -3.0000:-0.8750)
    xr = xCoord(cadr(dbComputeBBoxNoNLP(cv)))
    nPin(cv "P1" "output" list(xr + 1.5 1.0))
    nPin(cv "P0" "output" list(xr + 1.5 0.625))
    schCheck(cv) dbSave(cv)
    fprintf(nLog "%s check markers=%L\n" cv~>cellName length(setof(s cv~>shapes s~>objType == "marker")))
    nDump(cv) dbClose(cv)
  cv = dbOpenCellViewByType(nLib "MULT2" "symbol" "schematicSymbol" "w")
    dbCreateLine(cv list("device" "drawing") list(0.2500:0.6250 1.2500:0.6250 1.2500:-0.6250 0.2500:-0.6250 0.2500:0.6250))
    dbCreateLabel(cv list("device" "label") 0.7500:0.5650 "MULT 2b" "upperCenter" "R0" "stick" 0.06)
    nSymPin(cv "A1" "input" 0.0000:0.3750 0.2500:0.3750 0.2800:0.3750 "centerLeft")
    nSymPin(cv "A0" "input" 0.0000:0.1250 0.2500:0.1250 0.2800:0.1250 "centerLeft")
    nSymPin(cv "B1" "input" 0.0000:-0.1250 0.2500:-0.1250 0.2800:-0.1250 "centerLeft")
    nSymPin(cv "B0" "input" 0.0000:-0.3750 0.2500:-0.3750 0.2800:-0.3750 "centerLeft")
    nSymPin(cv "P1" "output" 1.5000:0.3750 1.2500:0.3750 1.2200:0.3750 "centerRight")
    nSymPin(cv "P0" "output" 1.5000:0.1250 1.2500:0.1250 1.2200:0.1250 "centerRight")
    nSymPin(cv "VDD" "inputOutput" 0.7500:0.8750 0.7500:0.6250 nil nil)
    nSymPin(cv "VSS" "inputOutput" 0.7500:-0.8750 0.7500:-0.6250 nil nil)
    dbCreateLabel(cv list("annotate" "drawing8") 0.7500:-0.9750 "[@cellName]" "upperCenter" "R0" "stick" 0.045)~>labelType = "NLPLabel"
    nSymFinish(cv list(0.0000:-0.8750 1.5000:0.8750))
  ; ---- RELU
  cv = dbOpenCellViewByType(nLib "RELU" "schematic" "schematic" "w")
    x = 0.0
    x = 0.0
    inst = schCreateInst(cv dbOpenCellViewByType(nLib "NOR3" "symbol") "I0" list(x 0.0) "R0")
    nStubAuto(cv inst "A" 0.375 "NZ_CON")
    nStubAuto(cv inst "B" 0.375 "NG_S")
    nStubAuto(cv inst "C" 0.375 "NG_C")
    nStubAuto(cv inst "Y" 0.375 "Z1")
    nStubAuto(cv inst "VDD" 0.375 "VDD")
    nStubAuto(cv inst "VSS" 0.375 "VSS")
    x = x + (xCoord(cadr(inst~>master~>bBox)) - xCoord(car(inst~>master~>bBox))) + 2.25
    inst = schCreateInst(cv dbOpenCellViewByType(nLib "AOI211" "symbol") "I1" list(x 0.0) "R0")
    nStubAuto(cv inst "A" 0.375 "NZ_CON")
    nStubAuto(cv inst "B" 0.375 "NG_S")
    nStubAuto(cv inst "C" 0.375 "NZ_SN")
    nStubAuto(cv inst "D" 0.375 "NG_C")
    nStubAuto(cv inst "Y" 0.375 "Z0")
    nStubAuto(cv inst "VDD" 0.375 "VDD")
    nStubAuto(cv inst "VSS" 0.375 "VSS")
    x = x + (xCoord(cadr(inst~>master~>bBox)) - xCoord(car(inst~>master~>bBox))) + 2.25
    nPin(cv "NZ_CON" "input" -3.0000:1.0000)
    nPin(cv "NZ_SN" "input" -3.0000:0.6250)
    nPin(cv "NG_S" "input" -3.0000:0.2500)
    nPin(cv "NG_C" "input" -3.0000:-0.1250)
    nPin(cv "VDD" "inputOutput" -3.0000:-0.5000)
    nPin(cv "VSS" "inputOutput" -3.0000:-0.8750)
    xr = xCoord(cadr(dbComputeBBoxNoNLP(cv)))
    nPin(cv "Z1" "output" list(xr + 1.5 1.0))
    nPin(cv "Z0" "output" list(xr + 1.5 0.625))
    schCheck(cv) dbSave(cv)
    fprintf(nLog "%s check markers=%L\n" cv~>cellName length(setof(s cv~>shapes s~>objType == "marker")))
    nDump(cv) dbClose(cv)
  cv = dbOpenCellViewByType(nLib "RELU" "symbol" "schematicSymbol" "w")
    dbCreateLine(cv list("device" "drawing") list(0.2500:0.6250 1.6250:0.6250 1.6250:-0.6250 0.2500:-0.6250 0.2500:0.6250))
    dbCreateLabel(cv list("device" "label") 0.9375:0.5650 "ReLU" "upperCenter" "R0" "stick" 0.06)
    nSymPin(cv "NZ_CON" "input" 0.0000:0.3750 0.2500:0.3750 0.2800:0.3750 "centerLeft")
    nSymPin(cv "NZ_SN" "input" 0.0000:0.1250 0.2500:0.1250 0.2800:0.1250 "centerLeft")
    nSymPin(cv "NG_S" "input" 0.0000:-0.1250 0.2500:-0.1250 0.2800:-0.1250 "centerLeft")
    nSymPin(cv "NG_C" "input" 0.0000:-0.3750 0.2500:-0.3750 0.2800:-0.3750 "centerLeft")
    nSymPin(cv "Z1" "output" 1.8750:0.3750 1.6250:0.3750 1.5950:0.3750 "centerRight")
    nSymPin(cv "Z0" "output" 1.8750:0.1250 1.6250:0.1250 1.5950:0.1250 "centerRight")
    nSymPin(cv "VDD" "inputOutput" 1.0000:0.8750 1.0000:0.6250 nil nil)
    nSymPin(cv "VSS" "inputOutput" 1.0000:-0.8750 1.0000:-0.6250 nil nil)
    dbCreateLabel(cv list("annotate" "drawing8") 1.0000:-0.9750 "[@cellName]" "upperCenter" "R0" "stick" 0.045)~>labelType = "NLPLabel"
    nSymFinish(cv list(0.0000:-0.8750 1.8750:0.8750))
  ; ---- NEURON
  cv = dbOpenCellViewByType(nLib "NEURON" "schematic" "schematic" "w")
    x = 0.0
    x = 0.0
    inst = schCreateInst(cv dbOpenCellViewByType(nLib "MULT2" "symbol") "U0" list(x 0.0) "R0")
    nStubAuto(cv inst "A1" 0.375 "X0_1")
    nStubAuto(cv inst "A0" 0.375 "X0_0")
    nStubAuto(cv inst "B1" 0.375 "W0_1")
    nStubAuto(cv inst "B0" 0.375 "W0_0")
    nStubAuto(cv inst "P1" 0.375 "PA1")
    nStubAuto(cv inst "P0" 0.375 "PA0")
    nStubAuto(cv inst "VDD" 0.375 "VDD")
    nStubAuto(cv inst "VSS" 0.375 "VSS")
    x = x + (xCoord(cadr(inst~>master~>bBox)) - xCoord(car(inst~>master~>bBox))) + 2.25
    inst = schCreateInst(cv dbOpenCellViewByType(nLib "MULT2" "symbol") "U1" list(x 0.0) "R0")
    nStubAuto(cv inst "A1" 0.375 "X1_1")
    nStubAuto(cv inst "A0" 0.375 "X1_0")
    nStubAuto(cv inst "B1" 0.375 "W1_1")
    nStubAuto(cv inst "B0" 0.375 "W1_0")
    nStubAuto(cv inst "P1" 0.375 "PB1")
    nStubAuto(cv inst "P0" 0.375 "PB0")
    nStubAuto(cv inst "VDD" 0.375 "VDD")
    nStubAuto(cv inst "VSS" 0.375 "VSS")
    x = x + (xCoord(cadr(inst~>master~>bBox)) - xCoord(car(inst~>master~>bBox))) + 2.25
    inst = schCreateInst(cv dbOpenCellViewByType(nLib "FA_MIRROR" "symbol") "U2" list(x 0.0) "R0")
    nStubAuto(cv inst "A" 0.375 "B_0")
    nStubAuto(cv inst "B" 0.375 "PA0")
    nStubAuto(cv inst "C" 0.375 "PB0")
    nStubAuto(cv inst "CON" 0.375 "NZ_CON")
    nStubAuto(cv inst "SN" 0.375 "NZ_SN")
    nStubAuto(cv inst "VDD" 0.375 "VDD")
    nStubAuto(cv inst "VSS" 0.375 "VSS")
    x = x + (xCoord(cadr(inst~>master~>bBox)) - xCoord(car(inst~>master~>bBox))) + 2.25
    inst = schCreateInst(cv dbOpenCellViewByType(nLib "FA_MIRROR" "symbol") "U3" list(x 0.0) "R0")
    nStubAuto(cv inst "A" 0.375 "B_1")
    nStubAuto(cv inst "B" 0.375 "PA1")
    nStubAuto(cv inst "C" 0.375 "PB1")
    nStubAuto(cv inst "CON" 0.375 "NG_CON")
    nStubAuto(cv inst "SN" 0.375 "NG_SN")
    nStubAuto(cv inst "VDD" 0.375 "VDD")
    nStubAuto(cv inst "VSS" 0.375 "VSS")
    x = x + (xCoord(cadr(inst~>master~>bBox)) - xCoord(car(inst~>master~>bBox))) + 2.25
    x = 0.0
    inst = schCreateInst(cv dbOpenCellViewByType(nLib "INV" "symbol") "U4" list(x -2.5) "R0")
    nStubAuto(cv inst "A" 0.375 "NG_SN")
    nStubAuto(cv inst "Y" 0.375 "NG_S")
    nStubAuto(cv inst "VDD" 0.375 "VDD")
    nStubAuto(cv inst "VSS" 0.375 "VSS")
    x = x + (xCoord(cadr(inst~>master~>bBox)) - xCoord(car(inst~>master~>bBox))) + 2.25
    inst = schCreateInst(cv dbOpenCellViewByType(nLib "INV" "symbol") "U5" list(x -2.5) "R0")
    nStubAuto(cv inst "A" 0.375 "NG_CON")
    nStubAuto(cv inst "Y" 0.375 "NG_C")
    nStubAuto(cv inst "VDD" 0.375 "VDD")
    nStubAuto(cv inst "VSS" 0.375 "VSS")
    x = x + (xCoord(cadr(inst~>master~>bBox)) - xCoord(car(inst~>master~>bBox))) + 2.25
    inst = schCreateInst(cv dbOpenCellViewByType(nLib "RELU" "symbol") "U6" list(x -2.5) "R0")
    nStubAuto(cv inst "NZ_CON" 0.375 "NZ_CON")
    nStubAuto(cv inst "NZ_SN" 0.375 "NZ_SN")
    nStubAuto(cv inst "NG_S" 0.375 "NG_S")
    nStubAuto(cv inst "NG_C" 0.375 "NG_C")
    nStubAuto(cv inst "Z1" 0.375 "Z1")
    nStubAuto(cv inst "Z0" 0.375 "Z0")
    nStubAuto(cv inst "VDD" 0.375 "VDD")
    nStubAuto(cv inst "VSS" 0.375 "VSS")
    x = x + (xCoord(cadr(inst~>master~>bBox)) - xCoord(car(inst~>master~>bBox))) + 2.25
    inst = schCreateInst(cv dbOpenCellViewByType(nLib "TIELO" "symbol") "U7" list(x -2.5) "R0")
    nStubAuto(cv inst "Y" 0.375 "Z2")
    nStubAuto(cv inst "VDD" 0.375 "VDD")
    nStubAuto(cv inst "VSS" 0.375 "VSS")
    x = x + (xCoord(cadr(inst~>master~>bBox)) - xCoord(car(inst~>master~>bBox))) + 2.25
    nPin(cv "X0_1" "input" -3.0000:1.0000)
    nPin(cv "X0_0" "input" -3.0000:0.6250)
    nPin(cv "W0_1" "input" -3.0000:0.2500)
    nPin(cv "W0_0" "input" -3.0000:-0.1250)
    nPin(cv "X1_1" "input" -3.0000:-0.5000)
    nPin(cv "X1_0" "input" -3.0000:-0.8750)
    nPin(cv "W1_1" "input" -3.0000:-1.2500)
    nPin(cv "W1_0" "input" -3.0000:-1.6250)
    nPin(cv "B_1" "input" -3.0000:-2.0000)
    nPin(cv "B_0" "input" -3.0000:-2.3750)
    nPin(cv "VDD" "inputOutput" -3.0000:-2.7500)
    nPin(cv "VSS" "inputOutput" -3.0000:-3.1250)
    xr = xCoord(cadr(dbComputeBBoxNoNLP(cv)))
    nPin(cv "Z2" "output" list(xr + 1.5 1.0))
    nPin(cv "Z1" "output" list(xr + 1.5 0.625))
    nPin(cv "Z0" "output" list(xr + 1.5 0.25))
    schCheck(cv) dbSave(cv)
    fprintf(nLog "%s check markers=%L\n" cv~>cellName length(setof(s cv~>shapes s~>objType == "marker")))
    nDump(cv) dbClose(cv)
  cv = dbOpenCellViewByType(nLib "NEURON" "symbol" "schematicSymbol" "w")
    dbCreateLine(cv list("device" "drawing") list(0.2500:1.3750 1.2500:1.3750 1.2500:-1.3750 0.2500:-1.3750 0.2500:1.3750))
    dbCreateLabel(cv list("device" "label") 0.7500:1.3150 "NEURON" "upperCenter" "R0" "stick" 0.06)
    nSymPin(cv "X0_1" "input" 0.0000:1.1250 0.2500:1.1250 0.2800:1.1250 "centerLeft")
    nSymPin(cv "X0_0" "input" 0.0000:0.8750 0.2500:0.8750 0.2800:0.8750 "centerLeft")
    nSymPin(cv "W0_1" "input" 0.0000:0.6250 0.2500:0.6250 0.2800:0.6250 "centerLeft")
    nSymPin(cv "W0_0" "input" 0.0000:0.3750 0.2500:0.3750 0.2800:0.3750 "centerLeft")
    nSymPin(cv "X1_1" "input" 0.0000:0.1250 0.2500:0.1250 0.2800:0.1250 "centerLeft")
    nSymPin(cv "X1_0" "input" 0.0000:-0.1250 0.2500:-0.1250 0.2800:-0.1250 "centerLeft")
    nSymPin(cv "W1_1" "input" 0.0000:-0.3750 0.2500:-0.3750 0.2800:-0.3750 "centerLeft")
    nSymPin(cv "W1_0" "input" 0.0000:-0.6250 0.2500:-0.6250 0.2800:-0.6250 "centerLeft")
    nSymPin(cv "B_1" "input" 0.0000:-0.8750 0.2500:-0.8750 0.2800:-0.8750 "centerLeft")
    nSymPin(cv "B_0" "input" 0.0000:-1.1250 0.2500:-1.1250 0.2800:-1.1250 "centerLeft")
    nSymPin(cv "Z2" "output" 1.5000:1.1250 1.2500:1.1250 1.2200:1.1250 "centerRight")
    nSymPin(cv "Z1" "output" 1.5000:0.8750 1.2500:0.8750 1.2200:0.8750 "centerRight")
    nSymPin(cv "Z0" "output" 1.5000:0.6250 1.2500:0.6250 1.2200:0.6250 "centerRight")
    nSymPin(cv "VDD" "inputOutput" 0.7500:1.6250 0.7500:1.3750 nil nil)
    nSymPin(cv "VSS" "inputOutput" 0.7500:-1.6250 0.7500:-1.3750 nil nil)
    dbCreateLabel(cv list("annotate" "drawing8") 0.7500:-1.7250 "[@cellName]" "upperCenter" "R0" "stick" 0.045)~>labelType = "NLPLabel"
    nSymFinish(cv list(0.0000:-1.6250 1.5000:1.6250))
) t)
when(errset.errset fprintf(nLog "ERROR %L\n" errset.errset))
close(nLog)
exit()
