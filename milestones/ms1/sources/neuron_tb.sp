* ECE555 MS1 neuron: functional check over all 243 legal input combinations
.INCLUDE "/srv/auto/apps-store/data/asap7PDK-2022/asap7PDK_r1p7/models/hspice/7nm_TT_160803.pm"
.INCLUDE "neuron_netlist.sp"
.TEMP 25.0
.options artist=2 ingold=2 parhier=local post=1 accurate=1 method=gear measdgt=5
vdd0 VDD 0 0.9
vss0 VSS 0 0
vX0_1 X0_1 0 pwl(0 0.9 3.2400e-08 0.9 3.2420e-08 0.0)
vX0_0 X0_0 0 pwl(0 0.9 3.2400e-08 0.9 3.2420e-08 0.0 6.4800e-08 0.0 6.4820e-08 0.9)
vW0_1 W0_1 0 pwl(0 0.9 1.0800e-08 0.9 1.0820e-08 0.0 3.2400e-08 0.0 3.2420e-08 0.9 4.3200e-08 0.9 4.3220e-08 0.0 6.4800e-08 0.0 6.4820e-08 0.9 7.5600e-08 0.9 7.5620e-08 0.0)
vW0_0 W0_0 0 pwl(0 0.9 1.0800e-08 0.9 1.0820e-08 0.0 2.1600e-08 0.0 2.1620e-08 0.9 4.3200e-08 0.9 4.3220e-08 0.0 5.4000e-08 0.0 5.4020e-08 0.9 7.5600e-08 0.9 7.5620e-08 0.0 8.6400e-08 0.0 8.6420e-08 0.9)
vX1_1 X1_1 0 pwl(0 0.9 3.6000e-09 0.9 3.6200e-09 0.0 1.0800e-08 0.0 1.0820e-08 0.9 1.4400e-08 0.9 1.4420e-08 0.0 2.1600e-08 0.0 2.1620e-08 0.9 2.5200e-08 0.9 2.5220e-08 0.0 3.2400e-08 0.0 3.2420e-08 0.9 3.6000e-08 0.9 3.6020e-08 0.0 4.3200e-08 0.0 4.3220e-08 0.9 4.6800e-08 0.9 4.6820e-08 0.0 5.4000e-08 0.0 5.4020e-08 0.9 5.7600e-08 0.9 5.7620e-08 0.0 6.4800e-08 0.0 6.4820e-08 0.9 6.8400e-08 0.9 6.8420e-08 0.0 7.5600e-08 0.0 7.5620e-08 0.9 7.9200e-08 0.9 7.9220e-08 0.0 8.6400e-08 0.0 8.6420e-08 0.9 9.0000e-08 0.9 9.0020e-08 0.0)
vX1_0 X1_0 0 pwl(0 0.9 3.6000e-09 0.9 3.6200e-09 0.0 7.2000e-09 0.0 7.2200e-09 0.9 1.4400e-08 0.9 1.4420e-08 0.0 1.8000e-08 0.0 1.8020e-08 0.9 2.5200e-08 0.9 2.5220e-08 0.0 2.8800e-08 0.0 2.8820e-08 0.9 3.6000e-08 0.9 3.6020e-08 0.0 3.9600e-08 0.0 3.9620e-08 0.9 4.6800e-08 0.9 4.6820e-08 0.0 5.0400e-08 0.0 5.0420e-08 0.9 5.7600e-08 0.9 5.7620e-08 0.0 6.1200e-08 0.0 6.1220e-08 0.9 6.8400e-08 0.9 6.8420e-08 0.0 7.2000e-08 0.0 7.2020e-08 0.9 7.9200e-08 0.9 7.9220e-08 0.0 8.2800e-08 0.0 8.2820e-08 0.9 9.0000e-08 0.9 9.0020e-08 0.0 9.3600e-08 0.0 9.3620e-08 0.9)
vW1_1 W1_1 0 pwl(0 0.9 1.2000e-09 0.9 1.2200e-09 0.0 3.6000e-09 0.0 3.6200e-09 0.9 4.8000e-09 0.9 4.8200e-09 0.0 7.2000e-09 0.0 7.2200e-09 0.9 8.4000e-09 0.9 8.4200e-09 0.0 1.0800e-08 0.0 1.0820e-08 0.9 1.2000e-08 0.9 1.2020e-08 0.0 1.4400e-08 0.0 1.4420e-08 0.9 1.5600e-08 0.9 1.5620e-08 0.0 1.8000e-08 0.0 1.8020e-08 0.9 1.9200e-08 0.9 1.9220e-08 0.0 2.1600e-08 0.0 2.1620e-08 0.9 2.2800e-08 0.9 2.2820e-08 0.0 2.5200e-08 0.0 2.5220e-08 0.9 2.6400e-08 0.9 2.6420e-08 0.0 2.8800e-08 0.0 2.8820e-08 0.9 3.0000e-08 0.9 3.0020e-08 0.0 3.2400e-08 0.0 3.2420e-08 0.9 3.3600e-08 0.9 3.3620e-08 0.0 3.6000e-08 0.0 3.6020e-08 0.9 3.7200e-08 0.9 3.7220e-08 0.0 3.9600e-08 0.0 3.9620e-08 0.9 4.0800e-08 0.9 4.0820e-08 0.0 4.3200e-08 0.0 4.3220e-08 0.9 4.4400e-08 0.9 4.4420e-08 0.0 4.6800e-08 0.0 4.6820e-08 0.9 4.8000e-08 0.9 4.8020e-08 0.0 5.0400e-08 0.0 5.0420e-08 0.9 5.1600e-08 0.9 5.1620e-08 0.0 5.4000e-08 0.0 5.4020e-08 0.9 5.5200e-08 0.9 5.5220e-08 0.0 5.7600e-08 0.0 5.7620e-08 0.9 5.8800e-08 0.9 5.8820e-08 0.0 6.1200e-08 0.0 6.1220e-08 0.9 6.2400e-08 0.9 6.2420e-08 0.0 6.4800e-08 0.0 6.4820e-08 0.9 6.6000e-08 0.9 6.6020e-08 0.0 6.8400e-08 0.0 6.8420e-08 0.9 6.9600e-08 0.9 6.9620e-08 0.0 7.2000e-08 0.0 7.2020e-08 0.9 7.3200e-08 0.9 7.3220e-08 0.0 7.5600e-08 0.0 7.5620e-08 0.9 7.6800e-08 0.9 7.6820e-08 0.0 7.9200e-08 0.0 7.9220e-08 0.9 8.0400e-08 0.9 8.0420e-08 0.0 8.2800e-08 0.0 8.2820e-08 0.9 8.4000e-08 0.9 8.4020e-08 0.0 8.6400e-08 0.0 8.6420e-08 0.9 8.7600e-08 0.9 8.7620e-08 0.0 9.0000e-08 0.0 9.0020e-08 0.9 9.1200e-08 0.9 9.1220e-08 0.0 9.3600e-08 0.0 9.3620e-08 0.9 9.4800e-08 0.9 9.4820e-08 0.0)
vW1_0 W1_0 0 pwl(0 0.9 1.2000e-09 0.9 1.2200e-09 0.0 2.4000e-09 0.0 2.4200e-09 0.9 4.8000e-09 0.9 4.8200e-09 0.0 6.0000e-09 0.0 6.0200e-09 0.9 8.4000e-09 0.9 8.4200e-09 0.0 9.6000e-09 0.0 9.6200e-09 0.9 1.2000e-08 0.9 1.2020e-08 0.0 1.3200e-08 0.0 1.3220e-08 0.9 1.5600e-08 0.9 1.5620e-08 0.0 1.6800e-08 0.0 1.6820e-08 0.9 1.9200e-08 0.9 1.9220e-08 0.0 2.0400e-08 0.0 2.0420e-08 0.9 2.2800e-08 0.9 2.2820e-08 0.0 2.4000e-08 0.0 2.4020e-08 0.9 2.6400e-08 0.9 2.6420e-08 0.0 2.7600e-08 0.0 2.7620e-08 0.9 3.0000e-08 0.9 3.0020e-08 0.0 3.1200e-08 0.0 3.1220e-08 0.9 3.3600e-08 0.9 3.3620e-08 0.0 3.4800e-08 0.0 3.4820e-08 0.9 3.7200e-08 0.9 3.7220e-08 0.0 3.8400e-08 0.0 3.8420e-08 0.9 4.0800e-08 0.9 4.0820e-08 0.0 4.2000e-08 0.0 4.2020e-08 0.9 4.4400e-08 0.9 4.4420e-08 0.0 4.5600e-08 0.0 4.5620e-08 0.9 4.8000e-08 0.9 4.8020e-08 0.0 4.9200e-08 0.0 4.9220e-08 0.9 5.1600e-08 0.9 5.1620e-08 0.0 5.2800e-08 0.0 5.2820e-08 0.9 5.5200e-08 0.9 5.5220e-08 0.0 5.6400e-08 0.0 5.6420e-08 0.9 5.8800e-08 0.9 5.8820e-08 0.0 6.0000e-08 0.0 6.0020e-08 0.9 6.2400e-08 0.9 6.2420e-08 0.0 6.3600e-08 0.0 6.3620e-08 0.9 6.6000e-08 0.9 6.6020e-08 0.0 6.7200e-08 0.0 6.7220e-08 0.9 6.9600e-08 0.9 6.9620e-08 0.0 7.0800e-08 0.0 7.0820e-08 0.9 7.3200e-08 0.9 7.3220e-08 0.0 7.4400e-08 0.0 7.4420e-08 0.9 7.6800e-08 0.9 7.6820e-08 0.0 7.8000e-08 0.0 7.8020e-08 0.9 8.0400e-08 0.9 8.0420e-08 0.0 8.1600e-08 0.0 8.1620e-08 0.9 8.4000e-08 0.9 8.4020e-08 0.0 8.5200e-08 0.0 8.5220e-08 0.9 8.7600e-08 0.9 8.7620e-08 0.0 8.8800e-08 0.0 8.8820e-08 0.9 9.1200e-08 0.9 9.1220e-08 0.0 9.2400e-08 0.0 9.2420e-08 0.9 9.4800e-08 0.9 9.4820e-08 0.0 9.6000e-08 0.0 9.6020e-08 0.9)
vB_1 B_1 0 pwl(0 0.9 4.0000e-10 0.9 4.2000e-10 0.0 1.2000e-09 0.0 1.2200e-09 0.9 1.6000e-09 0.9 1.6200e-09 0.0 2.4000e-09 0.0 2.4200e-09 0.9 2.8000e-09 0.9 2.8200e-09 0.0 3.6000e-09 0.0 3.6200e-09 0.9 4.0000e-09 0.9 4.0200e-09 0.0 4.8000e-09 0.0 4.8200e-09 0.9 5.2000e-09 0.9 5.2200e-09 0.0 6.0000e-09 0.0 6.0200e-09 0.9 6.4000e-09 0.9 6.4200e-09 0.0 7.2000e-09 0.0 7.2200e-09 0.9 7.6000e-09 0.9 7.6200e-09 0.0 8.4000e-09 0.0 8.4200e-09 0.9 8.8000e-09 0.9 8.8200e-09 0.0 9.6000e-09 0.0 9.6200e-09 0.9 1.0000e-08 0.9 1.0020e-08 0.0 1.0800e-08 0.0 1.0820e-08 0.9 1.1200e-08 0.9 1.1220e-08 0.0 1.2000e-08 0.0 1.2020e-08 0.9 1.2400e-08 0.9 1.2420e-08 0.0 1.3200e-08 0.0 1.3220e-08 0.9 1.3600e-08 0.9 1.3620e-08 0.0 1.4400e-08 0.0 1.4420e-08 0.9 1.4800e-08 0.9 1.4820e-08 0.0 1.5600e-08 0.0 1.5620e-08 0.9 1.6000e-08 0.9 1.6020e-08 0.0 1.6800e-08 0.0 1.6820e-08 0.9 1.7200e-08 0.9 1.7220e-08 0.0 1.8000e-08 0.0 1.8020e-08 0.9 1.8400e-08 0.9 1.8420e-08 0.0 1.9200e-08 0.0 1.9220e-08 0.9 1.9600e-08 0.9 1.9620e-08 0.0 2.0400e-08 0.0 2.0420e-08 0.9 2.0800e-08 0.9 2.0820e-08 0.0 2.1600e-08 0.0 2.1620e-08 0.9 2.2000e-08 0.9 2.2020e-08 0.0 2.2800e-08 0.0 2.2820e-08 0.9 2.3200e-08 0.9 2.3220e-08 0.0 2.4000e-08 0.0 2.4020e-08 0.9 2.4400e-08 0.9 2.4420e-08 0.0 2.5200e-08 0.0 2.5220e-08 0.9 2.5600e-08 0.9 2.5620e-08 0.0 2.6400e-08 0.0 2.6420e-08 0.9 2.6800e-08 0.9 2.6820e-08 0.0 2.7600e-08 0.0 2.7620e-08 0.9 2.8000e-08 0.9 2.8020e-08 0.0 2.8800e-08 0.0 2.8820e-08 0.9 2.9200e-08 0.9 2.9220e-08 0.0 3.0000e-08 0.0 3.0020e-08 0.9 3.0400e-08 0.9 3.0420e-08 0.0 3.1200e-08 0.0 3.1220e-08 0.9 3.1600e-08 0.9 3.1620e-08 0.0 3.2400e-08 0.0 3.2420e-08 0.9 3.2800e-08 0.9 3.2820e-08 0.0 3.3600e-08 0.0 3.3620e-08 0.9 3.4000e-08 0.9 3.4020e-08 0.0 3.4800e-08 0.0 3.4820e-08 0.9 3.5200e-08 0.9 3.5220e-08 0.0 3.6000e-08 0.0 3.6020e-08 0.9 3.6400e-08 0.9 3.6420e-08 0.0 3.7200e-08 0.0 3.7220e-08 0.9 3.7600e-08 0.9 3.7620e-08 0.0 3.8400e-08 0.0 3.8420e-08 0.9 3.8800e-08 0.9 3.8820e-08 0.0 3.9600e-08 0.0 3.9620e-08 0.9 4.0000e-08 0.9 4.0020e-08 0.0 4.0800e-08 0.0 4.0820e-08 0.9 4.1200e-08 0.9 4.1220e-08 0.0 4.2000e-08 0.0 4.2020e-08 0.9 4.2400e-08 0.9 4.2420e-08 0.0 4.3200e-08 0.0 4.3220e-08 0.9 4.3600e-08 0.9 4.3620e-08 0.0 4.4400e-08 0.0 4.4420e-08 0.9 4.4800e-08 0.9 4.4820e-08 0.0 4.5600e-08 0.0 4.5620e-08 0.9 4.6000e-08 0.9 4.6020e-08 0.0 4.6800e-08 0.0 4.6820e-08 0.9 4.7200e-08 0.9 4.7220e-08 0.0 4.8000e-08 0.0 4.8020e-08 0.9 4.8400e-08 0.9 4.8420e-08 0.0 4.9200e-08 0.0 4.9220e-08 0.9 4.9600e-08 0.9 4.9620e-08 0.0 5.0400e-08 0.0 5.0420e-08 0.9 5.0800e-08 0.9 5.0820e-08 0.0 5.1600e-08 0.0 5.1620e-08 0.9 5.2000e-08 0.9 5.2020e-08 0.0 5.2800e-08 0.0 5.2820e-08 0.9 5.3200e-08 0.9 5.3220e-08 0.0 5.4000e-08 0.0 5.4020e-08 0.9 5.4400e-08 0.9 5.4420e-08 0.0 5.5200e-08 0.0 5.5220e-08 0.9 5.5600e-08 0.9 5.5620e-08 0.0 5.6400e-08 0.0 5.6420e-08 0.9 5.6800e-08 0.9 5.6820e-08 0.0 5.7600e-08 0.0 5.7620e-08 0.9 5.8000e-08 0.9 5.8020e-08 0.0 5.8800e-08 0.0 5.8820e-08 0.9 5.9200e-08 0.9 5.9220e-08 0.0 6.0000e-08 0.0 6.0020e-08 0.9 6.0400e-08 0.9 6.0420e-08 0.0 6.1200e-08 0.0 6.1220e-08 0.9 6.1600e-08 0.9 6.1620e-08 0.0 6.2400e-08 0.0 6.2420e-08 0.9 6.2800e-08 0.9 6.2820e-08 0.0 6.3600e-08 0.0 6.3620e-08 0.9 6.4000e-08 0.9 6.4020e-08 0.0 6.4800e-08 0.0 6.4820e-08 0.9 6.5200e-08 0.9 6.5220e-08 0.0 6.6000e-08 0.0 6.6020e-08 0.9 6.6400e-08 0.9 6.6420e-08 0.0 6.7200e-08 0.0 6.7220e-08 0.9 6.7600e-08 0.9 6.7620e-08 0.0 6.8400e-08 0.0 6.8420e-08 0.9 6.8800e-08 0.9 6.8820e-08 0.0 6.9600e-08 0.0 6.9620e-08 0.9 7.0000e-08 0.9 7.0020e-08 0.0 7.0800e-08 0.0 7.0820e-08 0.9 7.1200e-08 0.9 7.1220e-08 0.0 7.2000e-08 0.0 7.2020e-08 0.9 7.2400e-08 0.9 7.2420e-08 0.0 7.3200e-08 0.0 7.3220e-08 0.9 7.3600e-08 0.9 7.3620e-08 0.0 7.4400e-08 0.0 7.4420e-08 0.9 7.4800e-08 0.9 7.4820e-08 0.0 7.5600e-08 0.0 7.5620e-08 0.9 7.6000e-08 0.9 7.6020e-08 0.0 7.6800e-08 0.0 7.6820e-08 0.9 7.7200e-08 0.9 7.7220e-08 0.0 7.8000e-08 0.0 7.8020e-08 0.9 7.8400e-08 0.9 7.8420e-08 0.0 7.9200e-08 0.0 7.9220e-08 0.9 7.9600e-08 0.9 7.9620e-08 0.0 8.0400e-08 0.0 8.0420e-08 0.9 8.0800e-08 0.9 8.0820e-08 0.0 8.1600e-08 0.0 8.1620e-08 0.9 8.2000e-08 0.9 8.2020e-08 0.0 8.2800e-08 0.0 8.2820e-08 0.9 8.3200e-08 0.9 8.3220e-08 0.0 8.4000e-08 0.0 8.4020e-08 0.9 8.4400e-08 0.9 8.4420e-08 0.0 8.5200e-08 0.0 8.5220e-08 0.9 8.5600e-08 0.9 8.5620e-08 0.0 8.6400e-08 0.0 8.6420e-08 0.9 8.6800e-08 0.9 8.6820e-08 0.0 8.7600e-08 0.0 8.7620e-08 0.9 8.8000e-08 0.9 8.8020e-08 0.0 8.8800e-08 0.0 8.8820e-08 0.9 8.9200e-08 0.9 8.9220e-08 0.0 9.0000e-08 0.0 9.0020e-08 0.9 9.0400e-08 0.9 9.0420e-08 0.0 9.1200e-08 0.0 9.1220e-08 0.9 9.1600e-08 0.9 9.1620e-08 0.0 9.2400e-08 0.0 9.2420e-08 0.9 9.2800e-08 0.9 9.2820e-08 0.0 9.3600e-08 0.0 9.3620e-08 0.9 9.4000e-08 0.9 9.4020e-08 0.0 9.4800e-08 0.0 9.4820e-08 0.9 9.5200e-08 0.9 9.5220e-08 0.0 9.6000e-08 0.0 9.6020e-08 0.9 9.6400e-08 0.9 9.6420e-08 0.0)
vB_0 B_0 0 pwl(0 0.9 4.0000e-10 0.9 4.2000e-10 0.0 8.0000e-10 0.0 8.2000e-10 0.9 1.6000e-09 0.9 1.6200e-09 0.0 2.0000e-09 0.0 2.0200e-09 0.9 2.8000e-09 0.9 2.8200e-09 0.0 3.2000e-09 0.0 3.2200e-09 0.9 4.0000e-09 0.9 4.0200e-09 0.0 4.4000e-09 0.0 4.4200e-09 0.9 5.2000e-09 0.9 5.2200e-09 0.0 5.6000e-09 0.0 5.6200e-09 0.9 6.4000e-09 0.9 6.4200e-09 0.0 6.8000e-09 0.0 6.8200e-09 0.9 7.6000e-09 0.9 7.6200e-09 0.0 8.0000e-09 0.0 8.0200e-09 0.9 8.8000e-09 0.9 8.8200e-09 0.0 9.2000e-09 0.0 9.2200e-09 0.9 1.0000e-08 0.9 1.0020e-08 0.0 1.0400e-08 0.0 1.0420e-08 0.9 1.1200e-08 0.9 1.1220e-08 0.0 1.1600e-08 0.0 1.1620e-08 0.9 1.2400e-08 0.9 1.2420e-08 0.0 1.2800e-08 0.0 1.2820e-08 0.9 1.3600e-08 0.9 1.3620e-08 0.0 1.4000e-08 0.0 1.4020e-08 0.9 1.4800e-08 0.9 1.4820e-08 0.0 1.5200e-08 0.0 1.5220e-08 0.9 1.6000e-08 0.9 1.6020e-08 0.0 1.6400e-08 0.0 1.6420e-08 0.9 1.7200e-08 0.9 1.7220e-08 0.0 1.7600e-08 0.0 1.7620e-08 0.9 1.8400e-08 0.9 1.8420e-08 0.0 1.8800e-08 0.0 1.8820e-08 0.9 1.9600e-08 0.9 1.9620e-08 0.0 2.0000e-08 0.0 2.0020e-08 0.9 2.0800e-08 0.9 2.0820e-08 0.0 2.1200e-08 0.0 2.1220e-08 0.9 2.2000e-08 0.9 2.2020e-08 0.0 2.2400e-08 0.0 2.2420e-08 0.9 2.3200e-08 0.9 2.3220e-08 0.0 2.3600e-08 0.0 2.3620e-08 0.9 2.4400e-08 0.9 2.4420e-08 0.0 2.4800e-08 0.0 2.4820e-08 0.9 2.5600e-08 0.9 2.5620e-08 0.0 2.6000e-08 0.0 2.6020e-08 0.9 2.6800e-08 0.9 2.6820e-08 0.0 2.7200e-08 0.0 2.7220e-08 0.9 2.8000e-08 0.9 2.8020e-08 0.0 2.8400e-08 0.0 2.8420e-08 0.9 2.9200e-08 0.9 2.9220e-08 0.0 2.9600e-08 0.0 2.9620e-08 0.9 3.0400e-08 0.9 3.0420e-08 0.0 3.0800e-08 0.0 3.0820e-08 0.9 3.1600e-08 0.9 3.1620e-08 0.0 3.2000e-08 0.0 3.2020e-08 0.9 3.2800e-08 0.9 3.2820e-08 0.0 3.3200e-08 0.0 3.3220e-08 0.9 3.4000e-08 0.9 3.4020e-08 0.0 3.4400e-08 0.0 3.4420e-08 0.9 3.5200e-08 0.9 3.5220e-08 0.0 3.5600e-08 0.0 3.5620e-08 0.9 3.6400e-08 0.9 3.6420e-08 0.0 3.6800e-08 0.0 3.6820e-08 0.9 3.7600e-08 0.9 3.7620e-08 0.0 3.8000e-08 0.0 3.8020e-08 0.9 3.8800e-08 0.9 3.8820e-08 0.0 3.9200e-08 0.0 3.9220e-08 0.9 4.0000e-08 0.9 4.0020e-08 0.0 4.0400e-08 0.0 4.0420e-08 0.9 4.1200e-08 0.9 4.1220e-08 0.0 4.1600e-08 0.0 4.1620e-08 0.9 4.2400e-08 0.9 4.2420e-08 0.0 4.2800e-08 0.0 4.2820e-08 0.9 4.3600e-08 0.9 4.3620e-08 0.0 4.4000e-08 0.0 4.4020e-08 0.9 4.4800e-08 0.9 4.4820e-08 0.0 4.5200e-08 0.0 4.5220e-08 0.9 4.6000e-08 0.9 4.6020e-08 0.0 4.6400e-08 0.0 4.6420e-08 0.9 4.7200e-08 0.9 4.7220e-08 0.0 4.7600e-08 0.0 4.7620e-08 0.9 4.8400e-08 0.9 4.8420e-08 0.0 4.8800e-08 0.0 4.8820e-08 0.9 4.9600e-08 0.9 4.9620e-08 0.0 5.0000e-08 0.0 5.0020e-08 0.9 5.0800e-08 0.9 5.0820e-08 0.0 5.1200e-08 0.0 5.1220e-08 0.9 5.2000e-08 0.9 5.2020e-08 0.0 5.2400e-08 0.0 5.2420e-08 0.9 5.3200e-08 0.9 5.3220e-08 0.0 5.3600e-08 0.0 5.3620e-08 0.9 5.4400e-08 0.9 5.4420e-08 0.0 5.4800e-08 0.0 5.4820e-08 0.9 5.5600e-08 0.9 5.5620e-08 0.0 5.6000e-08 0.0 5.6020e-08 0.9 5.6800e-08 0.9 5.6820e-08 0.0 5.7200e-08 0.0 5.7220e-08 0.9 5.8000e-08 0.9 5.8020e-08 0.0 5.8400e-08 0.0 5.8420e-08 0.9 5.9200e-08 0.9 5.9220e-08 0.0 5.9600e-08 0.0 5.9620e-08 0.9 6.0400e-08 0.9 6.0420e-08 0.0 6.0800e-08 0.0 6.0820e-08 0.9 6.1600e-08 0.9 6.1620e-08 0.0 6.2000e-08 0.0 6.2020e-08 0.9 6.2800e-08 0.9 6.2820e-08 0.0 6.3200e-08 0.0 6.3220e-08 0.9 6.4000e-08 0.9 6.4020e-08 0.0 6.4400e-08 0.0 6.4420e-08 0.9 6.5200e-08 0.9 6.5220e-08 0.0 6.5600e-08 0.0 6.5620e-08 0.9 6.6400e-08 0.9 6.6420e-08 0.0 6.6800e-08 0.0 6.6820e-08 0.9 6.7600e-08 0.9 6.7620e-08 0.0 6.8000e-08 0.0 6.8020e-08 0.9 6.8800e-08 0.9 6.8820e-08 0.0 6.9200e-08 0.0 6.9220e-08 0.9 7.0000e-08 0.9 7.0020e-08 0.0 7.0400e-08 0.0 7.0420e-08 0.9 7.1200e-08 0.9 7.1220e-08 0.0 7.1600e-08 0.0 7.1620e-08 0.9 7.2400e-08 0.9 7.2420e-08 0.0 7.2800e-08 0.0 7.2820e-08 0.9 7.3600e-08 0.9 7.3620e-08 0.0 7.4000e-08 0.0 7.4020e-08 0.9 7.4800e-08 0.9 7.4820e-08 0.0 7.5200e-08 0.0 7.5220e-08 0.9 7.6000e-08 0.9 7.6020e-08 0.0 7.6400e-08 0.0 7.6420e-08 0.9 7.7200e-08 0.9 7.7220e-08 0.0 7.7600e-08 0.0 7.7620e-08 0.9 7.8400e-08 0.9 7.8420e-08 0.0 7.8800e-08 0.0 7.8820e-08 0.9 7.9600e-08 0.9 7.9620e-08 0.0 8.0000e-08 0.0 8.0020e-08 0.9 8.0800e-08 0.9 8.0820e-08 0.0 8.1200e-08 0.0 8.1220e-08 0.9 8.2000e-08 0.9 8.2020e-08 0.0 8.2400e-08 0.0 8.2420e-08 0.9 8.3200e-08 0.9 8.3220e-08 0.0 8.3600e-08 0.0 8.3620e-08 0.9 8.4400e-08 0.9 8.4420e-08 0.0 8.4800e-08 0.0 8.4820e-08 0.9 8.5600e-08 0.9 8.5620e-08 0.0 8.6000e-08 0.0 8.6020e-08 0.9 8.6800e-08 0.9 8.6820e-08 0.0 8.7200e-08 0.0 8.7220e-08 0.9 8.8000e-08 0.9 8.8020e-08 0.0 8.8400e-08 0.0 8.8420e-08 0.9 8.9200e-08 0.9 8.9220e-08 0.0 8.9600e-08 0.0 8.9620e-08 0.9 9.0400e-08 0.9 9.0420e-08 0.0 9.0800e-08 0.0 9.0820e-08 0.9 9.1600e-08 0.9 9.1620e-08 0.0 9.2000e-08 0.0 9.2020e-08 0.9 9.2800e-08 0.9 9.2820e-08 0.0 9.3200e-08 0.0 9.3220e-08 0.9 9.4000e-08 0.9 9.4020e-08 0.0 9.4400e-08 0.0 9.4420e-08 0.9 9.5200e-08 0.9 9.5220e-08 0.0 9.5600e-08 0.0 9.5620e-08 0.9 9.6400e-08 0.9 9.6420e-08 0.0 9.6800e-08 0.0 9.6820e-08 0.9)
cZ0 Z0 0 1f
cZ1 Z1 0 1f
cZ2 Z2 0 1f
.tran 1p 9.7200e-08
.measure tran z0_0 find v(Z0) at=3.9500e-10
.measure tran z1_0 find v(Z1) at=3.9500e-10
.measure tran z2_0 find v(Z2) at=3.9500e-10
.measure tran z0_1 find v(Z0) at=7.9500e-10
.measure tran z1_1 find v(Z1) at=7.9500e-10
.measure tran z2_1 find v(Z2) at=7.9500e-10
.measure tran z0_2 find v(Z0) at=1.1950e-09
.measure tran z1_2 find v(Z1) at=1.1950e-09
.measure tran z2_2 find v(Z2) at=1.1950e-09
.measure tran z0_3 find v(Z0) at=1.5950e-09
.measure tran z1_3 find v(Z1) at=1.5950e-09
.measure tran z2_3 find v(Z2) at=1.5950e-09
.measure tran z0_4 find v(Z0) at=1.9950e-09
.measure tran z1_4 find v(Z1) at=1.9950e-09
.measure tran z2_4 find v(Z2) at=1.9950e-09
.measure tran z0_5 find v(Z0) at=2.3950e-09
.measure tran z1_5 find v(Z1) at=2.3950e-09
.measure tran z2_5 find v(Z2) at=2.3950e-09
.measure tran z0_6 find v(Z0) at=2.7950e-09
.measure tran z1_6 find v(Z1) at=2.7950e-09
.measure tran z2_6 find v(Z2) at=2.7950e-09
.measure tran z0_7 find v(Z0) at=3.1950e-09
.measure tran z1_7 find v(Z1) at=3.1950e-09
.measure tran z2_7 find v(Z2) at=3.1950e-09
.measure tran z0_8 find v(Z0) at=3.5950e-09
.measure tran z1_8 find v(Z1) at=3.5950e-09
.measure tran z2_8 find v(Z2) at=3.5950e-09
.measure tran z0_9 find v(Z0) at=3.9950e-09
.measure tran z1_9 find v(Z1) at=3.9950e-09
.measure tran z2_9 find v(Z2) at=3.9950e-09
.measure tran z0_10 find v(Z0) at=4.3950e-09
.measure tran z1_10 find v(Z1) at=4.3950e-09
.measure tran z2_10 find v(Z2) at=4.3950e-09
.measure tran z0_11 find v(Z0) at=4.7950e-09
.measure tran z1_11 find v(Z1) at=4.7950e-09
.measure tran z2_11 find v(Z2) at=4.7950e-09
.measure tran z0_12 find v(Z0) at=5.1950e-09
.measure tran z1_12 find v(Z1) at=5.1950e-09
.measure tran z2_12 find v(Z2) at=5.1950e-09
.measure tran z0_13 find v(Z0) at=5.5950e-09
.measure tran z1_13 find v(Z1) at=5.5950e-09
.measure tran z2_13 find v(Z2) at=5.5950e-09
.measure tran z0_14 find v(Z0) at=5.9950e-09
.measure tran z1_14 find v(Z1) at=5.9950e-09
.measure tran z2_14 find v(Z2) at=5.9950e-09
.measure tran z0_15 find v(Z0) at=6.3950e-09
.measure tran z1_15 find v(Z1) at=6.3950e-09
.measure tran z2_15 find v(Z2) at=6.3950e-09
.measure tran z0_16 find v(Z0) at=6.7950e-09
.measure tran z1_16 find v(Z1) at=6.7950e-09
.measure tran z2_16 find v(Z2) at=6.7950e-09
.measure tran z0_17 find v(Z0) at=7.1950e-09
.measure tran z1_17 find v(Z1) at=7.1950e-09
.measure tran z2_17 find v(Z2) at=7.1950e-09
.measure tran z0_18 find v(Z0) at=7.5950e-09
.measure tran z1_18 find v(Z1) at=7.5950e-09
.measure tran z2_18 find v(Z2) at=7.5950e-09
.measure tran z0_19 find v(Z0) at=7.9950e-09
.measure tran z1_19 find v(Z1) at=7.9950e-09
.measure tran z2_19 find v(Z2) at=7.9950e-09
.measure tran z0_20 find v(Z0) at=8.3950e-09
.measure tran z1_20 find v(Z1) at=8.3950e-09
.measure tran z2_20 find v(Z2) at=8.3950e-09
.measure tran z0_21 find v(Z0) at=8.7950e-09
.measure tran z1_21 find v(Z1) at=8.7950e-09
.measure tran z2_21 find v(Z2) at=8.7950e-09
.measure tran z0_22 find v(Z0) at=9.1950e-09
.measure tran z1_22 find v(Z1) at=9.1950e-09
.measure tran z2_22 find v(Z2) at=9.1950e-09
.measure tran z0_23 find v(Z0) at=9.5950e-09
.measure tran z1_23 find v(Z1) at=9.5950e-09
.measure tran z2_23 find v(Z2) at=9.5950e-09
.measure tran z0_24 find v(Z0) at=9.9950e-09
.measure tran z1_24 find v(Z1) at=9.9950e-09
.measure tran z2_24 find v(Z2) at=9.9950e-09
.measure tran z0_25 find v(Z0) at=1.0395e-08
.measure tran z1_25 find v(Z1) at=1.0395e-08
.measure tran z2_25 find v(Z2) at=1.0395e-08
.measure tran z0_26 find v(Z0) at=1.0795e-08
.measure tran z1_26 find v(Z1) at=1.0795e-08
.measure tran z2_26 find v(Z2) at=1.0795e-08
.measure tran z0_27 find v(Z0) at=1.1195e-08
.measure tran z1_27 find v(Z1) at=1.1195e-08
.measure tran z2_27 find v(Z2) at=1.1195e-08
.measure tran z0_28 find v(Z0) at=1.1595e-08
.measure tran z1_28 find v(Z1) at=1.1595e-08
.measure tran z2_28 find v(Z2) at=1.1595e-08
.measure tran z0_29 find v(Z0) at=1.1995e-08
.measure tran z1_29 find v(Z1) at=1.1995e-08
.measure tran z2_29 find v(Z2) at=1.1995e-08
.measure tran z0_30 find v(Z0) at=1.2395e-08
.measure tran z1_30 find v(Z1) at=1.2395e-08
.measure tran z2_30 find v(Z2) at=1.2395e-08
.measure tran z0_31 find v(Z0) at=1.2795e-08
.measure tran z1_31 find v(Z1) at=1.2795e-08
.measure tran z2_31 find v(Z2) at=1.2795e-08
.measure tran z0_32 find v(Z0) at=1.3195e-08
.measure tran z1_32 find v(Z1) at=1.3195e-08
.measure tran z2_32 find v(Z2) at=1.3195e-08
.measure tran z0_33 find v(Z0) at=1.3595e-08
.measure tran z1_33 find v(Z1) at=1.3595e-08
.measure tran z2_33 find v(Z2) at=1.3595e-08
.measure tran z0_34 find v(Z0) at=1.3995e-08
.measure tran z1_34 find v(Z1) at=1.3995e-08
.measure tran z2_34 find v(Z2) at=1.3995e-08
.measure tran z0_35 find v(Z0) at=1.4395e-08
.measure tran z1_35 find v(Z1) at=1.4395e-08
.measure tran z2_35 find v(Z2) at=1.4395e-08
.measure tran z0_36 find v(Z0) at=1.4795e-08
.measure tran z1_36 find v(Z1) at=1.4795e-08
.measure tran z2_36 find v(Z2) at=1.4795e-08
.measure tran z0_37 find v(Z0) at=1.5195e-08
.measure tran z1_37 find v(Z1) at=1.5195e-08
.measure tran z2_37 find v(Z2) at=1.5195e-08
.measure tran z0_38 find v(Z0) at=1.5595e-08
.measure tran z1_38 find v(Z1) at=1.5595e-08
.measure tran z2_38 find v(Z2) at=1.5595e-08
.measure tran z0_39 find v(Z0) at=1.5995e-08
.measure tran z1_39 find v(Z1) at=1.5995e-08
.measure tran z2_39 find v(Z2) at=1.5995e-08
.measure tran z0_40 find v(Z0) at=1.6395e-08
.measure tran z1_40 find v(Z1) at=1.6395e-08
.measure tran z2_40 find v(Z2) at=1.6395e-08
.measure tran z0_41 find v(Z0) at=1.6795e-08
.measure tran z1_41 find v(Z1) at=1.6795e-08
.measure tran z2_41 find v(Z2) at=1.6795e-08
.measure tran z0_42 find v(Z0) at=1.7195e-08
.measure tran z1_42 find v(Z1) at=1.7195e-08
.measure tran z2_42 find v(Z2) at=1.7195e-08
.measure tran z0_43 find v(Z0) at=1.7595e-08
.measure tran z1_43 find v(Z1) at=1.7595e-08
.measure tran z2_43 find v(Z2) at=1.7595e-08
.measure tran z0_44 find v(Z0) at=1.7995e-08
.measure tran z1_44 find v(Z1) at=1.7995e-08
.measure tran z2_44 find v(Z2) at=1.7995e-08
.measure tran z0_45 find v(Z0) at=1.8395e-08
.measure tran z1_45 find v(Z1) at=1.8395e-08
.measure tran z2_45 find v(Z2) at=1.8395e-08
.measure tran z0_46 find v(Z0) at=1.8795e-08
.measure tran z1_46 find v(Z1) at=1.8795e-08
.measure tran z2_46 find v(Z2) at=1.8795e-08
.measure tran z0_47 find v(Z0) at=1.9195e-08
.measure tran z1_47 find v(Z1) at=1.9195e-08
.measure tran z2_47 find v(Z2) at=1.9195e-08
.measure tran z0_48 find v(Z0) at=1.9595e-08
.measure tran z1_48 find v(Z1) at=1.9595e-08
.measure tran z2_48 find v(Z2) at=1.9595e-08
.measure tran z0_49 find v(Z0) at=1.9995e-08
.measure tran z1_49 find v(Z1) at=1.9995e-08
.measure tran z2_49 find v(Z2) at=1.9995e-08
.measure tran z0_50 find v(Z0) at=2.0395e-08
.measure tran z1_50 find v(Z1) at=2.0395e-08
.measure tran z2_50 find v(Z2) at=2.0395e-08
.measure tran z0_51 find v(Z0) at=2.0795e-08
.measure tran z1_51 find v(Z1) at=2.0795e-08
.measure tran z2_51 find v(Z2) at=2.0795e-08
.measure tran z0_52 find v(Z0) at=2.1195e-08
.measure tran z1_52 find v(Z1) at=2.1195e-08
.measure tran z2_52 find v(Z2) at=2.1195e-08
.measure tran z0_53 find v(Z0) at=2.1595e-08
.measure tran z1_53 find v(Z1) at=2.1595e-08
.measure tran z2_53 find v(Z2) at=2.1595e-08
.measure tran z0_54 find v(Z0) at=2.1995e-08
.measure tran z1_54 find v(Z1) at=2.1995e-08
.measure tran z2_54 find v(Z2) at=2.1995e-08
.measure tran z0_55 find v(Z0) at=2.2395e-08
.measure tran z1_55 find v(Z1) at=2.2395e-08
.measure tran z2_55 find v(Z2) at=2.2395e-08
.measure tran z0_56 find v(Z0) at=2.2795e-08
.measure tran z1_56 find v(Z1) at=2.2795e-08
.measure tran z2_56 find v(Z2) at=2.2795e-08
.measure tran z0_57 find v(Z0) at=2.3195e-08
.measure tran z1_57 find v(Z1) at=2.3195e-08
.measure tran z2_57 find v(Z2) at=2.3195e-08
.measure tran z0_58 find v(Z0) at=2.3595e-08
.measure tran z1_58 find v(Z1) at=2.3595e-08
.measure tran z2_58 find v(Z2) at=2.3595e-08
.measure tran z0_59 find v(Z0) at=2.3995e-08
.measure tran z1_59 find v(Z1) at=2.3995e-08
.measure tran z2_59 find v(Z2) at=2.3995e-08
.measure tran z0_60 find v(Z0) at=2.4395e-08
.measure tran z1_60 find v(Z1) at=2.4395e-08
.measure tran z2_60 find v(Z2) at=2.4395e-08
.measure tran z0_61 find v(Z0) at=2.4795e-08
.measure tran z1_61 find v(Z1) at=2.4795e-08
.measure tran z2_61 find v(Z2) at=2.4795e-08
.measure tran z0_62 find v(Z0) at=2.5195e-08
.measure tran z1_62 find v(Z1) at=2.5195e-08
.measure tran z2_62 find v(Z2) at=2.5195e-08
.measure tran z0_63 find v(Z0) at=2.5595e-08
.measure tran z1_63 find v(Z1) at=2.5595e-08
.measure tran z2_63 find v(Z2) at=2.5595e-08
.measure tran z0_64 find v(Z0) at=2.5995e-08
.measure tran z1_64 find v(Z1) at=2.5995e-08
.measure tran z2_64 find v(Z2) at=2.5995e-08
.measure tran z0_65 find v(Z0) at=2.6395e-08
.measure tran z1_65 find v(Z1) at=2.6395e-08
.measure tran z2_65 find v(Z2) at=2.6395e-08
.measure tran z0_66 find v(Z0) at=2.6795e-08
.measure tran z1_66 find v(Z1) at=2.6795e-08
.measure tran z2_66 find v(Z2) at=2.6795e-08
.measure tran z0_67 find v(Z0) at=2.7195e-08
.measure tran z1_67 find v(Z1) at=2.7195e-08
.measure tran z2_67 find v(Z2) at=2.7195e-08
.measure tran z0_68 find v(Z0) at=2.7595e-08
.measure tran z1_68 find v(Z1) at=2.7595e-08
.measure tran z2_68 find v(Z2) at=2.7595e-08
.measure tran z0_69 find v(Z0) at=2.7995e-08
.measure tran z1_69 find v(Z1) at=2.7995e-08
.measure tran z2_69 find v(Z2) at=2.7995e-08
.measure tran z0_70 find v(Z0) at=2.8395e-08
.measure tran z1_70 find v(Z1) at=2.8395e-08
.measure tran z2_70 find v(Z2) at=2.8395e-08
.measure tran z0_71 find v(Z0) at=2.8795e-08
.measure tran z1_71 find v(Z1) at=2.8795e-08
.measure tran z2_71 find v(Z2) at=2.8795e-08
.measure tran z0_72 find v(Z0) at=2.9195e-08
.measure tran z1_72 find v(Z1) at=2.9195e-08
.measure tran z2_72 find v(Z2) at=2.9195e-08
.measure tran z0_73 find v(Z0) at=2.9595e-08
.measure tran z1_73 find v(Z1) at=2.9595e-08
.measure tran z2_73 find v(Z2) at=2.9595e-08
.measure tran z0_74 find v(Z0) at=2.9995e-08
.measure tran z1_74 find v(Z1) at=2.9995e-08
.measure tran z2_74 find v(Z2) at=2.9995e-08
.measure tran z0_75 find v(Z0) at=3.0395e-08
.measure tran z1_75 find v(Z1) at=3.0395e-08
.measure tran z2_75 find v(Z2) at=3.0395e-08
.measure tran z0_76 find v(Z0) at=3.0795e-08
.measure tran z1_76 find v(Z1) at=3.0795e-08
.measure tran z2_76 find v(Z2) at=3.0795e-08
.measure tran z0_77 find v(Z0) at=3.1195e-08
.measure tran z1_77 find v(Z1) at=3.1195e-08
.measure tran z2_77 find v(Z2) at=3.1195e-08
.measure tran z0_78 find v(Z0) at=3.1595e-08
.measure tran z1_78 find v(Z1) at=3.1595e-08
.measure tran z2_78 find v(Z2) at=3.1595e-08
.measure tran z0_79 find v(Z0) at=3.1995e-08
.measure tran z1_79 find v(Z1) at=3.1995e-08
.measure tran z2_79 find v(Z2) at=3.1995e-08
.measure tran z0_80 find v(Z0) at=3.2395e-08
.measure tran z1_80 find v(Z1) at=3.2395e-08
.measure tran z2_80 find v(Z2) at=3.2395e-08
.measure tran z0_81 find v(Z0) at=3.2795e-08
.measure tran z1_81 find v(Z1) at=3.2795e-08
.measure tran z2_81 find v(Z2) at=3.2795e-08
.measure tran z0_82 find v(Z0) at=3.3195e-08
.measure tran z1_82 find v(Z1) at=3.3195e-08
.measure tran z2_82 find v(Z2) at=3.3195e-08
.measure tran z0_83 find v(Z0) at=3.3595e-08
.measure tran z1_83 find v(Z1) at=3.3595e-08
.measure tran z2_83 find v(Z2) at=3.3595e-08
.measure tran z0_84 find v(Z0) at=3.3995e-08
.measure tran z1_84 find v(Z1) at=3.3995e-08
.measure tran z2_84 find v(Z2) at=3.3995e-08
.measure tran z0_85 find v(Z0) at=3.4395e-08
.measure tran z1_85 find v(Z1) at=3.4395e-08
.measure tran z2_85 find v(Z2) at=3.4395e-08
.measure tran z0_86 find v(Z0) at=3.4795e-08
.measure tran z1_86 find v(Z1) at=3.4795e-08
.measure tran z2_86 find v(Z2) at=3.4795e-08
.measure tran z0_87 find v(Z0) at=3.5195e-08
.measure tran z1_87 find v(Z1) at=3.5195e-08
.measure tran z2_87 find v(Z2) at=3.5195e-08
.measure tran z0_88 find v(Z0) at=3.5595e-08
.measure tran z1_88 find v(Z1) at=3.5595e-08
.measure tran z2_88 find v(Z2) at=3.5595e-08
.measure tran z0_89 find v(Z0) at=3.5995e-08
.measure tran z1_89 find v(Z1) at=3.5995e-08
.measure tran z2_89 find v(Z2) at=3.5995e-08
.measure tran z0_90 find v(Z0) at=3.6395e-08
.measure tran z1_90 find v(Z1) at=3.6395e-08
.measure tran z2_90 find v(Z2) at=3.6395e-08
.measure tran z0_91 find v(Z0) at=3.6795e-08
.measure tran z1_91 find v(Z1) at=3.6795e-08
.measure tran z2_91 find v(Z2) at=3.6795e-08
.measure tran z0_92 find v(Z0) at=3.7195e-08
.measure tran z1_92 find v(Z1) at=3.7195e-08
.measure tran z2_92 find v(Z2) at=3.7195e-08
.measure tran z0_93 find v(Z0) at=3.7595e-08
.measure tran z1_93 find v(Z1) at=3.7595e-08
.measure tran z2_93 find v(Z2) at=3.7595e-08
.measure tran z0_94 find v(Z0) at=3.7995e-08
.measure tran z1_94 find v(Z1) at=3.7995e-08
.measure tran z2_94 find v(Z2) at=3.7995e-08
.measure tran z0_95 find v(Z0) at=3.8395e-08
.measure tran z1_95 find v(Z1) at=3.8395e-08
.measure tran z2_95 find v(Z2) at=3.8395e-08
.measure tran z0_96 find v(Z0) at=3.8795e-08
.measure tran z1_96 find v(Z1) at=3.8795e-08
.measure tran z2_96 find v(Z2) at=3.8795e-08
.measure tran z0_97 find v(Z0) at=3.9195e-08
.measure tran z1_97 find v(Z1) at=3.9195e-08
.measure tran z2_97 find v(Z2) at=3.9195e-08
.measure tran z0_98 find v(Z0) at=3.9595e-08
.measure tran z1_98 find v(Z1) at=3.9595e-08
.measure tran z2_98 find v(Z2) at=3.9595e-08
.measure tran z0_99 find v(Z0) at=3.9995e-08
.measure tran z1_99 find v(Z1) at=3.9995e-08
.measure tran z2_99 find v(Z2) at=3.9995e-08
.measure tran z0_100 find v(Z0) at=4.0395e-08
.measure tran z1_100 find v(Z1) at=4.0395e-08
.measure tran z2_100 find v(Z2) at=4.0395e-08
.measure tran z0_101 find v(Z0) at=4.0795e-08
.measure tran z1_101 find v(Z1) at=4.0795e-08
.measure tran z2_101 find v(Z2) at=4.0795e-08
.measure tran z0_102 find v(Z0) at=4.1195e-08
.measure tran z1_102 find v(Z1) at=4.1195e-08
.measure tran z2_102 find v(Z2) at=4.1195e-08
.measure tran z0_103 find v(Z0) at=4.1595e-08
.measure tran z1_103 find v(Z1) at=4.1595e-08
.measure tran z2_103 find v(Z2) at=4.1595e-08
.measure tran z0_104 find v(Z0) at=4.1995e-08
.measure tran z1_104 find v(Z1) at=4.1995e-08
.measure tran z2_104 find v(Z2) at=4.1995e-08
.measure tran z0_105 find v(Z0) at=4.2395e-08
.measure tran z1_105 find v(Z1) at=4.2395e-08
.measure tran z2_105 find v(Z2) at=4.2395e-08
.measure tran z0_106 find v(Z0) at=4.2795e-08
.measure tran z1_106 find v(Z1) at=4.2795e-08
.measure tran z2_106 find v(Z2) at=4.2795e-08
.measure tran z0_107 find v(Z0) at=4.3195e-08
.measure tran z1_107 find v(Z1) at=4.3195e-08
.measure tran z2_107 find v(Z2) at=4.3195e-08
.measure tran z0_108 find v(Z0) at=4.3595e-08
.measure tran z1_108 find v(Z1) at=4.3595e-08
.measure tran z2_108 find v(Z2) at=4.3595e-08
.measure tran z0_109 find v(Z0) at=4.3995e-08
.measure tran z1_109 find v(Z1) at=4.3995e-08
.measure tran z2_109 find v(Z2) at=4.3995e-08
.measure tran z0_110 find v(Z0) at=4.4395e-08
.measure tran z1_110 find v(Z1) at=4.4395e-08
.measure tran z2_110 find v(Z2) at=4.4395e-08
.measure tran z0_111 find v(Z0) at=4.4795e-08
.measure tran z1_111 find v(Z1) at=4.4795e-08
.measure tran z2_111 find v(Z2) at=4.4795e-08
.measure tran z0_112 find v(Z0) at=4.5195e-08
.measure tran z1_112 find v(Z1) at=4.5195e-08
.measure tran z2_112 find v(Z2) at=4.5195e-08
.measure tran z0_113 find v(Z0) at=4.5595e-08
.measure tran z1_113 find v(Z1) at=4.5595e-08
.measure tran z2_113 find v(Z2) at=4.5595e-08
.measure tran z0_114 find v(Z0) at=4.5995e-08
.measure tran z1_114 find v(Z1) at=4.5995e-08
.measure tran z2_114 find v(Z2) at=4.5995e-08
.measure tran z0_115 find v(Z0) at=4.6395e-08
.measure tran z1_115 find v(Z1) at=4.6395e-08
.measure tran z2_115 find v(Z2) at=4.6395e-08
.measure tran z0_116 find v(Z0) at=4.6795e-08
.measure tran z1_116 find v(Z1) at=4.6795e-08
.measure tran z2_116 find v(Z2) at=4.6795e-08
.measure tran z0_117 find v(Z0) at=4.7195e-08
.measure tran z1_117 find v(Z1) at=4.7195e-08
.measure tran z2_117 find v(Z2) at=4.7195e-08
.measure tran z0_118 find v(Z0) at=4.7595e-08
.measure tran z1_118 find v(Z1) at=4.7595e-08
.measure tran z2_118 find v(Z2) at=4.7595e-08
.measure tran z0_119 find v(Z0) at=4.7995e-08
.measure tran z1_119 find v(Z1) at=4.7995e-08
.measure tran z2_119 find v(Z2) at=4.7995e-08
.measure tran z0_120 find v(Z0) at=4.8395e-08
.measure tran z1_120 find v(Z1) at=4.8395e-08
.measure tran z2_120 find v(Z2) at=4.8395e-08
.measure tran z0_121 find v(Z0) at=4.8795e-08
.measure tran z1_121 find v(Z1) at=4.8795e-08
.measure tran z2_121 find v(Z2) at=4.8795e-08
.measure tran z0_122 find v(Z0) at=4.9195e-08
.measure tran z1_122 find v(Z1) at=4.9195e-08
.measure tran z2_122 find v(Z2) at=4.9195e-08
.measure tran z0_123 find v(Z0) at=4.9595e-08
.measure tran z1_123 find v(Z1) at=4.9595e-08
.measure tran z2_123 find v(Z2) at=4.9595e-08
.measure tran z0_124 find v(Z0) at=4.9995e-08
.measure tran z1_124 find v(Z1) at=4.9995e-08
.measure tran z2_124 find v(Z2) at=4.9995e-08
.measure tran z0_125 find v(Z0) at=5.0395e-08
.measure tran z1_125 find v(Z1) at=5.0395e-08
.measure tran z2_125 find v(Z2) at=5.0395e-08
.measure tran z0_126 find v(Z0) at=5.0795e-08
.measure tran z1_126 find v(Z1) at=5.0795e-08
.measure tran z2_126 find v(Z2) at=5.0795e-08
.measure tran z0_127 find v(Z0) at=5.1195e-08
.measure tran z1_127 find v(Z1) at=5.1195e-08
.measure tran z2_127 find v(Z2) at=5.1195e-08
.measure tran z0_128 find v(Z0) at=5.1595e-08
.measure tran z1_128 find v(Z1) at=5.1595e-08
.measure tran z2_128 find v(Z2) at=5.1595e-08
.measure tran z0_129 find v(Z0) at=5.1995e-08
.measure tran z1_129 find v(Z1) at=5.1995e-08
.measure tran z2_129 find v(Z2) at=5.1995e-08
.measure tran z0_130 find v(Z0) at=5.2395e-08
.measure tran z1_130 find v(Z1) at=5.2395e-08
.measure tran z2_130 find v(Z2) at=5.2395e-08
.measure tran z0_131 find v(Z0) at=5.2795e-08
.measure tran z1_131 find v(Z1) at=5.2795e-08
.measure tran z2_131 find v(Z2) at=5.2795e-08
.measure tran z0_132 find v(Z0) at=5.3195e-08
.measure tran z1_132 find v(Z1) at=5.3195e-08
.measure tran z2_132 find v(Z2) at=5.3195e-08
.measure tran z0_133 find v(Z0) at=5.3595e-08
.measure tran z1_133 find v(Z1) at=5.3595e-08
.measure tran z2_133 find v(Z2) at=5.3595e-08
.measure tran z0_134 find v(Z0) at=5.3995e-08
.measure tran z1_134 find v(Z1) at=5.3995e-08
.measure tran z2_134 find v(Z2) at=5.3995e-08
.measure tran z0_135 find v(Z0) at=5.4395e-08
.measure tran z1_135 find v(Z1) at=5.4395e-08
.measure tran z2_135 find v(Z2) at=5.4395e-08
.measure tran z0_136 find v(Z0) at=5.4795e-08
.measure tran z1_136 find v(Z1) at=5.4795e-08
.measure tran z2_136 find v(Z2) at=5.4795e-08
.measure tran z0_137 find v(Z0) at=5.5195e-08
.measure tran z1_137 find v(Z1) at=5.5195e-08
.measure tran z2_137 find v(Z2) at=5.5195e-08
.measure tran z0_138 find v(Z0) at=5.5595e-08
.measure tran z1_138 find v(Z1) at=5.5595e-08
.measure tran z2_138 find v(Z2) at=5.5595e-08
.measure tran z0_139 find v(Z0) at=5.5995e-08
.measure tran z1_139 find v(Z1) at=5.5995e-08
.measure tran z2_139 find v(Z2) at=5.5995e-08
.measure tran z0_140 find v(Z0) at=5.6395e-08
.measure tran z1_140 find v(Z1) at=5.6395e-08
.measure tran z2_140 find v(Z2) at=5.6395e-08
.measure tran z0_141 find v(Z0) at=5.6795e-08
.measure tran z1_141 find v(Z1) at=5.6795e-08
.measure tran z2_141 find v(Z2) at=5.6795e-08
.measure tran z0_142 find v(Z0) at=5.7195e-08
.measure tran z1_142 find v(Z1) at=5.7195e-08
.measure tran z2_142 find v(Z2) at=5.7195e-08
.measure tran z0_143 find v(Z0) at=5.7595e-08
.measure tran z1_143 find v(Z1) at=5.7595e-08
.measure tran z2_143 find v(Z2) at=5.7595e-08
.measure tran z0_144 find v(Z0) at=5.7995e-08
.measure tran z1_144 find v(Z1) at=5.7995e-08
.measure tran z2_144 find v(Z2) at=5.7995e-08
.measure tran z0_145 find v(Z0) at=5.8395e-08
.measure tran z1_145 find v(Z1) at=5.8395e-08
.measure tran z2_145 find v(Z2) at=5.8395e-08
.measure tran z0_146 find v(Z0) at=5.8795e-08
.measure tran z1_146 find v(Z1) at=5.8795e-08
.measure tran z2_146 find v(Z2) at=5.8795e-08
.measure tran z0_147 find v(Z0) at=5.9195e-08
.measure tran z1_147 find v(Z1) at=5.9195e-08
.measure tran z2_147 find v(Z2) at=5.9195e-08
.measure tran z0_148 find v(Z0) at=5.9595e-08
.measure tran z1_148 find v(Z1) at=5.9595e-08
.measure tran z2_148 find v(Z2) at=5.9595e-08
.measure tran z0_149 find v(Z0) at=5.9995e-08
.measure tran z1_149 find v(Z1) at=5.9995e-08
.measure tran z2_149 find v(Z2) at=5.9995e-08
.measure tran z0_150 find v(Z0) at=6.0395e-08
.measure tran z1_150 find v(Z1) at=6.0395e-08
.measure tran z2_150 find v(Z2) at=6.0395e-08
.measure tran z0_151 find v(Z0) at=6.0795e-08
.measure tran z1_151 find v(Z1) at=6.0795e-08
.measure tran z2_151 find v(Z2) at=6.0795e-08
.measure tran z0_152 find v(Z0) at=6.1195e-08
.measure tran z1_152 find v(Z1) at=6.1195e-08
.measure tran z2_152 find v(Z2) at=6.1195e-08
.measure tran z0_153 find v(Z0) at=6.1595e-08
.measure tran z1_153 find v(Z1) at=6.1595e-08
.measure tran z2_153 find v(Z2) at=6.1595e-08
.measure tran z0_154 find v(Z0) at=6.1995e-08
.measure tran z1_154 find v(Z1) at=6.1995e-08
.measure tran z2_154 find v(Z2) at=6.1995e-08
.measure tran z0_155 find v(Z0) at=6.2395e-08
.measure tran z1_155 find v(Z1) at=6.2395e-08
.measure tran z2_155 find v(Z2) at=6.2395e-08
.measure tran z0_156 find v(Z0) at=6.2795e-08
.measure tran z1_156 find v(Z1) at=6.2795e-08
.measure tran z2_156 find v(Z2) at=6.2795e-08
.measure tran z0_157 find v(Z0) at=6.3195e-08
.measure tran z1_157 find v(Z1) at=6.3195e-08
.measure tran z2_157 find v(Z2) at=6.3195e-08
.measure tran z0_158 find v(Z0) at=6.3595e-08
.measure tran z1_158 find v(Z1) at=6.3595e-08
.measure tran z2_158 find v(Z2) at=6.3595e-08
.measure tran z0_159 find v(Z0) at=6.3995e-08
.measure tran z1_159 find v(Z1) at=6.3995e-08
.measure tran z2_159 find v(Z2) at=6.3995e-08
.measure tran z0_160 find v(Z0) at=6.4395e-08
.measure tran z1_160 find v(Z1) at=6.4395e-08
.measure tran z2_160 find v(Z2) at=6.4395e-08
.measure tran z0_161 find v(Z0) at=6.4795e-08
.measure tran z1_161 find v(Z1) at=6.4795e-08
.measure tran z2_161 find v(Z2) at=6.4795e-08
.measure tran z0_162 find v(Z0) at=6.5195e-08
.measure tran z1_162 find v(Z1) at=6.5195e-08
.measure tran z2_162 find v(Z2) at=6.5195e-08
.measure tran z0_163 find v(Z0) at=6.5595e-08
.measure tran z1_163 find v(Z1) at=6.5595e-08
.measure tran z2_163 find v(Z2) at=6.5595e-08
.measure tran z0_164 find v(Z0) at=6.5995e-08
.measure tran z1_164 find v(Z1) at=6.5995e-08
.measure tran z2_164 find v(Z2) at=6.5995e-08
.measure tran z0_165 find v(Z0) at=6.6395e-08
.measure tran z1_165 find v(Z1) at=6.6395e-08
.measure tran z2_165 find v(Z2) at=6.6395e-08
.measure tran z0_166 find v(Z0) at=6.6795e-08
.measure tran z1_166 find v(Z1) at=6.6795e-08
.measure tran z2_166 find v(Z2) at=6.6795e-08
.measure tran z0_167 find v(Z0) at=6.7195e-08
.measure tran z1_167 find v(Z1) at=6.7195e-08
.measure tran z2_167 find v(Z2) at=6.7195e-08
.measure tran z0_168 find v(Z0) at=6.7595e-08
.measure tran z1_168 find v(Z1) at=6.7595e-08
.measure tran z2_168 find v(Z2) at=6.7595e-08
.measure tran z0_169 find v(Z0) at=6.7995e-08
.measure tran z1_169 find v(Z1) at=6.7995e-08
.measure tran z2_169 find v(Z2) at=6.7995e-08
.measure tran z0_170 find v(Z0) at=6.8395e-08
.measure tran z1_170 find v(Z1) at=6.8395e-08
.measure tran z2_170 find v(Z2) at=6.8395e-08
.measure tran z0_171 find v(Z0) at=6.8795e-08
.measure tran z1_171 find v(Z1) at=6.8795e-08
.measure tran z2_171 find v(Z2) at=6.8795e-08
.measure tran z0_172 find v(Z0) at=6.9195e-08
.measure tran z1_172 find v(Z1) at=6.9195e-08
.measure tran z2_172 find v(Z2) at=6.9195e-08
.measure tran z0_173 find v(Z0) at=6.9595e-08
.measure tran z1_173 find v(Z1) at=6.9595e-08
.measure tran z2_173 find v(Z2) at=6.9595e-08
.measure tran z0_174 find v(Z0) at=6.9995e-08
.measure tran z1_174 find v(Z1) at=6.9995e-08
.measure tran z2_174 find v(Z2) at=6.9995e-08
.measure tran z0_175 find v(Z0) at=7.0395e-08
.measure tran z1_175 find v(Z1) at=7.0395e-08
.measure tran z2_175 find v(Z2) at=7.0395e-08
.measure tran z0_176 find v(Z0) at=7.0795e-08
.measure tran z1_176 find v(Z1) at=7.0795e-08
.measure tran z2_176 find v(Z2) at=7.0795e-08
.measure tran z0_177 find v(Z0) at=7.1195e-08
.measure tran z1_177 find v(Z1) at=7.1195e-08
.measure tran z2_177 find v(Z2) at=7.1195e-08
.measure tran z0_178 find v(Z0) at=7.1595e-08
.measure tran z1_178 find v(Z1) at=7.1595e-08
.measure tran z2_178 find v(Z2) at=7.1595e-08
.measure tran z0_179 find v(Z0) at=7.1995e-08
.measure tran z1_179 find v(Z1) at=7.1995e-08
.measure tran z2_179 find v(Z2) at=7.1995e-08
.measure tran z0_180 find v(Z0) at=7.2395e-08
.measure tran z1_180 find v(Z1) at=7.2395e-08
.measure tran z2_180 find v(Z2) at=7.2395e-08
.measure tran z0_181 find v(Z0) at=7.2795e-08
.measure tran z1_181 find v(Z1) at=7.2795e-08
.measure tran z2_181 find v(Z2) at=7.2795e-08
.measure tran z0_182 find v(Z0) at=7.3195e-08
.measure tran z1_182 find v(Z1) at=7.3195e-08
.measure tran z2_182 find v(Z2) at=7.3195e-08
.measure tran z0_183 find v(Z0) at=7.3595e-08
.measure tran z1_183 find v(Z1) at=7.3595e-08
.measure tran z2_183 find v(Z2) at=7.3595e-08
.measure tran z0_184 find v(Z0) at=7.3995e-08
.measure tran z1_184 find v(Z1) at=7.3995e-08
.measure tran z2_184 find v(Z2) at=7.3995e-08
.measure tran z0_185 find v(Z0) at=7.4395e-08
.measure tran z1_185 find v(Z1) at=7.4395e-08
.measure tran z2_185 find v(Z2) at=7.4395e-08
.measure tran z0_186 find v(Z0) at=7.4795e-08
.measure tran z1_186 find v(Z1) at=7.4795e-08
.measure tran z2_186 find v(Z2) at=7.4795e-08
.measure tran z0_187 find v(Z0) at=7.5195e-08
.measure tran z1_187 find v(Z1) at=7.5195e-08
.measure tran z2_187 find v(Z2) at=7.5195e-08
.measure tran z0_188 find v(Z0) at=7.5595e-08
.measure tran z1_188 find v(Z1) at=7.5595e-08
.measure tran z2_188 find v(Z2) at=7.5595e-08
.measure tran z0_189 find v(Z0) at=7.5995e-08
.measure tran z1_189 find v(Z1) at=7.5995e-08
.measure tran z2_189 find v(Z2) at=7.5995e-08
.measure tran z0_190 find v(Z0) at=7.6395e-08
.measure tran z1_190 find v(Z1) at=7.6395e-08
.measure tran z2_190 find v(Z2) at=7.6395e-08
.measure tran z0_191 find v(Z0) at=7.6795e-08
.measure tran z1_191 find v(Z1) at=7.6795e-08
.measure tran z2_191 find v(Z2) at=7.6795e-08
.measure tran z0_192 find v(Z0) at=7.7195e-08
.measure tran z1_192 find v(Z1) at=7.7195e-08
.measure tran z2_192 find v(Z2) at=7.7195e-08
.measure tran z0_193 find v(Z0) at=7.7595e-08
.measure tran z1_193 find v(Z1) at=7.7595e-08
.measure tran z2_193 find v(Z2) at=7.7595e-08
.measure tran z0_194 find v(Z0) at=7.7995e-08
.measure tran z1_194 find v(Z1) at=7.7995e-08
.measure tran z2_194 find v(Z2) at=7.7995e-08
.measure tran z0_195 find v(Z0) at=7.8395e-08
.measure tran z1_195 find v(Z1) at=7.8395e-08
.measure tran z2_195 find v(Z2) at=7.8395e-08
.measure tran z0_196 find v(Z0) at=7.8795e-08
.measure tran z1_196 find v(Z1) at=7.8795e-08
.measure tran z2_196 find v(Z2) at=7.8795e-08
.measure tran z0_197 find v(Z0) at=7.9195e-08
.measure tran z1_197 find v(Z1) at=7.9195e-08
.measure tran z2_197 find v(Z2) at=7.9195e-08
.measure tran z0_198 find v(Z0) at=7.9595e-08
.measure tran z1_198 find v(Z1) at=7.9595e-08
.measure tran z2_198 find v(Z2) at=7.9595e-08
.measure tran z0_199 find v(Z0) at=7.9995e-08
.measure tran z1_199 find v(Z1) at=7.9995e-08
.measure tran z2_199 find v(Z2) at=7.9995e-08
.measure tran z0_200 find v(Z0) at=8.0395e-08
.measure tran z1_200 find v(Z1) at=8.0395e-08
.measure tran z2_200 find v(Z2) at=8.0395e-08
.measure tran z0_201 find v(Z0) at=8.0795e-08
.measure tran z1_201 find v(Z1) at=8.0795e-08
.measure tran z2_201 find v(Z2) at=8.0795e-08
.measure tran z0_202 find v(Z0) at=8.1195e-08
.measure tran z1_202 find v(Z1) at=8.1195e-08
.measure tran z2_202 find v(Z2) at=8.1195e-08
.measure tran z0_203 find v(Z0) at=8.1595e-08
.measure tran z1_203 find v(Z1) at=8.1595e-08
.measure tran z2_203 find v(Z2) at=8.1595e-08
.measure tran z0_204 find v(Z0) at=8.1995e-08
.measure tran z1_204 find v(Z1) at=8.1995e-08
.measure tran z2_204 find v(Z2) at=8.1995e-08
.measure tran z0_205 find v(Z0) at=8.2395e-08
.measure tran z1_205 find v(Z1) at=8.2395e-08
.measure tran z2_205 find v(Z2) at=8.2395e-08
.measure tran z0_206 find v(Z0) at=8.2795e-08
.measure tran z1_206 find v(Z1) at=8.2795e-08
.measure tran z2_206 find v(Z2) at=8.2795e-08
.measure tran z0_207 find v(Z0) at=8.3195e-08
.measure tran z1_207 find v(Z1) at=8.3195e-08
.measure tran z2_207 find v(Z2) at=8.3195e-08
.measure tran z0_208 find v(Z0) at=8.3595e-08
.measure tran z1_208 find v(Z1) at=8.3595e-08
.measure tran z2_208 find v(Z2) at=8.3595e-08
.measure tran z0_209 find v(Z0) at=8.3995e-08
.measure tran z1_209 find v(Z1) at=8.3995e-08
.measure tran z2_209 find v(Z2) at=8.3995e-08
.measure tran z0_210 find v(Z0) at=8.4395e-08
.measure tran z1_210 find v(Z1) at=8.4395e-08
.measure tran z2_210 find v(Z2) at=8.4395e-08
.measure tran z0_211 find v(Z0) at=8.4795e-08
.measure tran z1_211 find v(Z1) at=8.4795e-08
.measure tran z2_211 find v(Z2) at=8.4795e-08
.measure tran z0_212 find v(Z0) at=8.5195e-08
.measure tran z1_212 find v(Z1) at=8.5195e-08
.measure tran z2_212 find v(Z2) at=8.5195e-08
.measure tran z0_213 find v(Z0) at=8.5595e-08
.measure tran z1_213 find v(Z1) at=8.5595e-08
.measure tran z2_213 find v(Z2) at=8.5595e-08
.measure tran z0_214 find v(Z0) at=8.5995e-08
.measure tran z1_214 find v(Z1) at=8.5995e-08
.measure tran z2_214 find v(Z2) at=8.5995e-08
.measure tran z0_215 find v(Z0) at=8.6395e-08
.measure tran z1_215 find v(Z1) at=8.6395e-08
.measure tran z2_215 find v(Z2) at=8.6395e-08
.measure tran z0_216 find v(Z0) at=8.6795e-08
.measure tran z1_216 find v(Z1) at=8.6795e-08
.measure tran z2_216 find v(Z2) at=8.6795e-08
.measure tran z0_217 find v(Z0) at=8.7195e-08
.measure tran z1_217 find v(Z1) at=8.7195e-08
.measure tran z2_217 find v(Z2) at=8.7195e-08
.measure tran z0_218 find v(Z0) at=8.7595e-08
.measure tran z1_218 find v(Z1) at=8.7595e-08
.measure tran z2_218 find v(Z2) at=8.7595e-08
.measure tran z0_219 find v(Z0) at=8.7995e-08
.measure tran z1_219 find v(Z1) at=8.7995e-08
.measure tran z2_219 find v(Z2) at=8.7995e-08
.measure tran z0_220 find v(Z0) at=8.8395e-08
.measure tran z1_220 find v(Z1) at=8.8395e-08
.measure tran z2_220 find v(Z2) at=8.8395e-08
.measure tran z0_221 find v(Z0) at=8.8795e-08
.measure tran z1_221 find v(Z1) at=8.8795e-08
.measure tran z2_221 find v(Z2) at=8.8795e-08
.measure tran z0_222 find v(Z0) at=8.9195e-08
.measure tran z1_222 find v(Z1) at=8.9195e-08
.measure tran z2_222 find v(Z2) at=8.9195e-08
.measure tran z0_223 find v(Z0) at=8.9595e-08
.measure tran z1_223 find v(Z1) at=8.9595e-08
.measure tran z2_223 find v(Z2) at=8.9595e-08
.measure tran z0_224 find v(Z0) at=8.9995e-08
.measure tran z1_224 find v(Z1) at=8.9995e-08
.measure tran z2_224 find v(Z2) at=8.9995e-08
.measure tran z0_225 find v(Z0) at=9.0395e-08
.measure tran z1_225 find v(Z1) at=9.0395e-08
.measure tran z2_225 find v(Z2) at=9.0395e-08
.measure tran z0_226 find v(Z0) at=9.0795e-08
.measure tran z1_226 find v(Z1) at=9.0795e-08
.measure tran z2_226 find v(Z2) at=9.0795e-08
.measure tran z0_227 find v(Z0) at=9.1195e-08
.measure tran z1_227 find v(Z1) at=9.1195e-08
.measure tran z2_227 find v(Z2) at=9.1195e-08
.measure tran z0_228 find v(Z0) at=9.1595e-08
.measure tran z1_228 find v(Z1) at=9.1595e-08
.measure tran z2_228 find v(Z2) at=9.1595e-08
.measure tran z0_229 find v(Z0) at=9.1995e-08
.measure tran z1_229 find v(Z1) at=9.1995e-08
.measure tran z2_229 find v(Z2) at=9.1995e-08
.measure tran z0_230 find v(Z0) at=9.2395e-08
.measure tran z1_230 find v(Z1) at=9.2395e-08
.measure tran z2_230 find v(Z2) at=9.2395e-08
.measure tran z0_231 find v(Z0) at=9.2795e-08
.measure tran z1_231 find v(Z1) at=9.2795e-08
.measure tran z2_231 find v(Z2) at=9.2795e-08
.measure tran z0_232 find v(Z0) at=9.3195e-08
.measure tran z1_232 find v(Z1) at=9.3195e-08
.measure tran z2_232 find v(Z2) at=9.3195e-08
.measure tran z0_233 find v(Z0) at=9.3595e-08
.measure tran z1_233 find v(Z1) at=9.3595e-08
.measure tran z2_233 find v(Z2) at=9.3595e-08
.measure tran z0_234 find v(Z0) at=9.3995e-08
.measure tran z1_234 find v(Z1) at=9.3995e-08
.measure tran z2_234 find v(Z2) at=9.3995e-08
.measure tran z0_235 find v(Z0) at=9.4395e-08
.measure tran z1_235 find v(Z1) at=9.4395e-08
.measure tran z2_235 find v(Z2) at=9.4395e-08
.measure tran z0_236 find v(Z0) at=9.4795e-08
.measure tran z1_236 find v(Z1) at=9.4795e-08
.measure tran z2_236 find v(Z2) at=9.4795e-08
.measure tran z0_237 find v(Z0) at=9.5195e-08
.measure tran z1_237 find v(Z1) at=9.5195e-08
.measure tran z2_237 find v(Z2) at=9.5195e-08
.measure tran z0_238 find v(Z0) at=9.5595e-08
.measure tran z1_238 find v(Z1) at=9.5595e-08
.measure tran z2_238 find v(Z2) at=9.5595e-08
.measure tran z0_239 find v(Z0) at=9.5995e-08
.measure tran z1_239 find v(Z1) at=9.5995e-08
.measure tran z2_239 find v(Z2) at=9.5995e-08
.measure tran z0_240 find v(Z0) at=9.6395e-08
.measure tran z1_240 find v(Z1) at=9.6395e-08
.measure tran z2_240 find v(Z2) at=9.6395e-08
.measure tran z0_241 find v(Z0) at=9.6795e-08
.measure tran z1_241 find v(Z1) at=9.6795e-08
.measure tran z2_241 find v(Z2) at=9.6795e-08
.measure tran z0_242 find v(Z0) at=9.7195e-08
.measure tran z1_242 find v(Z1) at=9.7195e-08
.measure tran z2_242 find v(Z2) at=9.7195e-08
.end
