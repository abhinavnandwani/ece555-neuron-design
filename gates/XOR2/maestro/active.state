ADE simulation setup
Test ECE555_XNOR2_1: ECE555/XOR2/schematic, simulator hspiceD
Run mode: Single Run, Sweeps and Corners
