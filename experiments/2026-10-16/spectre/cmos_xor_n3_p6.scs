simulator lang=spectre
simulatorOptions options temp=25
simulator lang=spice
.include 'asap7_TT.pm'
simulator lang=spectre
VDD (vdd 0) vsource dc=0.9
M1 (n0 i0 j1 0) nmos_rvt l=20n nfin=3
M2 (j1 i4 0 0) nmos_rvt l=20n nfin=3
M3 (n0 i0 vdd vdd) pmos_rvt l=20n nfin=6
M4 (n0 i4 vdd vdd) pmos_rvt l=20n nfin=6
M5 (n1 n0 0 0) nmos_rvt l=20n nfin=3
M6 (n1 n0 vdd vdd) pmos_rvt l=20n nfin=6
M7 (n2 i1 0 0) nmos_rvt l=20n nfin=3
M8 (n2 i1 vdd vdd) pmos_rvt l=20n nfin=6
M9 (n3 i5 0 0) nmos_rvt l=20n nfin=3
M10 (n3 i5 vdd vdd) pmos_rvt l=20n nfin=6
M11 (n4 i1 j3 0) nmos_rvt l=20n nfin=3
M12 (j3 i5 0 0) nmos_rvt l=20n nfin=3
M13 (n4 n2 j5 0) nmos_rvt l=20n nfin=3
M14 (j5 n3 0 0) nmos_rvt l=20n nfin=3
M15 (n4 i1 j7 vdd) pmos_rvt l=20n nfin=6
M16 (n4 i5 j7 vdd) pmos_rvt l=20n nfin=6
M17 (j7 n2 vdd vdd) pmos_rvt l=20n nfin=6
M18 (j7 n3 vdd vdd) pmos_rvt l=20n nfin=6
M19 (n5 n1 j9 0) nmos_rvt l=20n nfin=3
M20 (j9 n4 0 0) nmos_rvt l=20n nfin=3
M21 (n5 n1 vdd vdd) pmos_rvt l=20n nfin=6
M22 (n5 n4 vdd vdd) pmos_rvt l=20n nfin=6
M23 (n6 n5 0 0) nmos_rvt l=20n nfin=3
M24 (n6 n5 vdd vdd) pmos_rvt l=20n nfin=6
M25 (n7 i2 j11 0) nmos_rvt l=20n nfin=3
M26 (j11 i6 0 0) nmos_rvt l=20n nfin=3
M27 (n7 i2 vdd vdd) pmos_rvt l=20n nfin=6
M28 (n7 i6 vdd vdd) pmos_rvt l=20n nfin=6
M29 (n8 n7 0 0) nmos_rvt l=20n nfin=3
M30 (n8 n7 vdd vdd) pmos_rvt l=20n nfin=6
M31 (n9 i3 0 0) nmos_rvt l=20n nfin=3
M32 (n9 i3 vdd vdd) pmos_rvt l=20n nfin=6
M33 (n10 i7 0 0) nmos_rvt l=20n nfin=3
M34 (n10 i7 vdd vdd) pmos_rvt l=20n nfin=6
M35 (n11 i3 j13 0) nmos_rvt l=20n nfin=3
M36 (j13 i7 0 0) nmos_rvt l=20n nfin=3
M37 (n11 n9 j15 0) nmos_rvt l=20n nfin=3
M38 (j15 n10 0 0) nmos_rvt l=20n nfin=3
M39 (n11 i3 j17 vdd) pmos_rvt l=20n nfin=6
M40 (n11 i7 j17 vdd) pmos_rvt l=20n nfin=6
M41 (j17 n9 vdd vdd) pmos_rvt l=20n nfin=6
M42 (j17 n10 vdd vdd) pmos_rvt l=20n nfin=6
M43 (n12 n8 j19 0) nmos_rvt l=20n nfin=3
M44 (j19 n11 0 0) nmos_rvt l=20n nfin=3
M45 (n12 n8 vdd vdd) pmos_rvt l=20n nfin=6
M46 (n12 n11 vdd vdd) pmos_rvt l=20n nfin=6
M47 (n13 n12 0 0) nmos_rvt l=20n nfin=3
M48 (n13 n12 vdd vdd) pmos_rvt l=20n nfin=6
M49 (n14 n1 j21 0) nmos_rvt l=20n nfin=3
M50 (j21 n8 0 0) nmos_rvt l=20n nfin=3
M51 (n14 n0 j23 0) nmos_rvt l=20n nfin=3
M52 (j23 n7 0 0) nmos_rvt l=20n nfin=3
M53 (n14 n1 j25 vdd) pmos_rvt l=20n nfin=6
M54 (n14 n8 j25 vdd) pmos_rvt l=20n nfin=6
M55 (j25 n0 vdd vdd) pmos_rvt l=20n nfin=6
M56 (j25 n7 vdd vdd) pmos_rvt l=20n nfin=6
M57 (n15 n14 0 0) nmos_rvt l=20n nfin=3
M58 (n15 n14 vdd vdd) pmos_rvt l=20n nfin=6
M59 (n16 i8 0 0) nmos_rvt l=20n nfin=3
M60 (n16 i8 vdd vdd) pmos_rvt l=20n nfin=6
M61 (n17 n14 j27 0) nmos_rvt l=20n nfin=3
M62 (j27 i8 0 0) nmos_rvt l=20n nfin=3
M63 (n17 n15 j29 0) nmos_rvt l=20n nfin=3
M64 (j29 n16 0 0) nmos_rvt l=20n nfin=3
M65 (n17 n14 j31 vdd) pmos_rvt l=20n nfin=6
M66 (n17 i8 j31 vdd) pmos_rvt l=20n nfin=6
M67 (j31 n15 vdd vdd) pmos_rvt l=20n nfin=6
M68 (j31 n16 vdd vdd) pmos_rvt l=20n nfin=6
M69 (n18 n1 j33 0) nmos_rvt l=20n nfin=3
M70 (j33 n8 0 0) nmos_rvt l=20n nfin=3
M71 (n18 n1 vdd vdd) pmos_rvt l=20n nfin=6
M72 (n18 n8 vdd vdd) pmos_rvt l=20n nfin=6
M73 (n19 n14 j35 0) nmos_rvt l=20n nfin=3
M74 (j35 i8 0 0) nmos_rvt l=20n nfin=3
M75 (n19 n14 vdd vdd) pmos_rvt l=20n nfin=6
M76 (n19 i8 vdd vdd) pmos_rvt l=20n nfin=6
M77 (n20 n18 j37 0) nmos_rvt l=20n nfin=3
M78 (j37 n19 0 0) nmos_rvt l=20n nfin=3
M79 (n20 n18 vdd vdd) pmos_rvt l=20n nfin=6
M80 (n20 n19 vdd vdd) pmos_rvt l=20n nfin=6
M81 (n21 n6 j39 0) nmos_rvt l=20n nfin=3
M82 (j39 n13 0 0) nmos_rvt l=20n nfin=3
M83 (n21 n5 j41 0) nmos_rvt l=20n nfin=3
M84 (j41 n12 0 0) nmos_rvt l=20n nfin=3
M85 (n21 n6 j43 vdd) pmos_rvt l=20n nfin=6
M86 (n21 n13 j43 vdd) pmos_rvt l=20n nfin=6
M87 (j43 n5 vdd vdd) pmos_rvt l=20n nfin=6
M88 (j43 n12 vdd vdd) pmos_rvt l=20n nfin=6
M89 (n22 n21 0 0) nmos_rvt l=20n nfin=3
M90 (n22 n21 vdd vdd) pmos_rvt l=20n nfin=6
M91 (n23 i9 0 0) nmos_rvt l=20n nfin=3
M92 (n23 i9 vdd vdd) pmos_rvt l=20n nfin=6
M93 (n24 n21 j45 0) nmos_rvt l=20n nfin=3
M94 (j45 i9 0 0) nmos_rvt l=20n nfin=3
M95 (n24 n22 j47 0) nmos_rvt l=20n nfin=3
M96 (j47 n23 0 0) nmos_rvt l=20n nfin=3
M97 (n24 n21 j49 vdd) pmos_rvt l=20n nfin=6
M98 (n24 i9 j49 vdd) pmos_rvt l=20n nfin=6
M99 (j49 n22 vdd vdd) pmos_rvt l=20n nfin=6
M100 (j49 n23 vdd vdd) pmos_rvt l=20n nfin=6
M101 (n25 n6 j51 0) nmos_rvt l=20n nfin=3
M102 (j51 n13 0 0) nmos_rvt l=20n nfin=3
M103 (n25 n6 vdd vdd) pmos_rvt l=20n nfin=6
M104 (n25 n13 vdd vdd) pmos_rvt l=20n nfin=6
M105 (n26 n21 j53 0) nmos_rvt l=20n nfin=3
M106 (j53 i9 0 0) nmos_rvt l=20n nfin=3
M107 (n26 n21 vdd vdd) pmos_rvt l=20n nfin=6
M108 (n26 i9 vdd vdd) pmos_rvt l=20n nfin=6
M109 (n27 n25 j55 0) nmos_rvt l=20n nfin=3
M110 (j55 n26 0 0) nmos_rvt l=20n nfin=3
M111 (n27 n25 vdd vdd) pmos_rvt l=20n nfin=6
M112 (n27 n26 vdd vdd) pmos_rvt l=20n nfin=6
M113 (n28 n27 0 0) nmos_rvt l=20n nfin=3
M114 (n28 n27 vdd vdd) pmos_rvt l=20n nfin=6
M115 (n29 n24 0 0) nmos_rvt l=20n nfin=3
M116 (n29 n24 vdd vdd) pmos_rvt l=20n nfin=6
M117 (n30 n20 0 0) nmos_rvt l=20n nfin=3
M118 (n30 n29 0 0) nmos_rvt l=20n nfin=3
M119 (n30 n20 j57 vdd) pmos_rvt l=20n nfin=6
M120 (j57 n29 vdd vdd) pmos_rvt l=20n nfin=6
M121 (n31 n30 0 0) nmos_rvt l=20n nfin=3
M122 (n31 n30 vdd vdd) pmos_rvt l=20n nfin=6
M123 (n32 n28 j59 0) nmos_rvt l=20n nfin=3
M124 (j59 n31 0 0) nmos_rvt l=20n nfin=3
M125 (n32 n28 vdd vdd) pmos_rvt l=20n nfin=6
M126 (n32 n31 vdd vdd) pmos_rvt l=20n nfin=6
M127 (n33 n32 0 0) nmos_rvt l=20n nfin=3
M128 (n33 n32 vdd vdd) pmos_rvt l=20n nfin=6
M129 (n34 n17 j61 0) nmos_rvt l=20n nfin=3
M130 (j61 n33 0 0) nmos_rvt l=20n nfin=3
M131 (n34 n17 vdd vdd) pmos_rvt l=20n nfin=6
M132 (n34 n33 vdd vdd) pmos_rvt l=20n nfin=6
M133 (n35 n34 0 0) nmos_rvt l=20n nfin=3
M134 (n35 n34 vdd vdd) pmos_rvt l=20n nfin=6
M135 (n36 n29 j63 0) nmos_rvt l=20n nfin=3
M136 (j63 n28 0 0) nmos_rvt l=20n nfin=3
M137 (n36 n29 vdd vdd) pmos_rvt l=20n nfin=6
M138 (n36 n28 vdd vdd) pmos_rvt l=20n nfin=6
M139 (n37 n36 0 0) nmos_rvt l=20n nfin=3
M140 (n37 n36 vdd vdd) pmos_rvt l=20n nfin=6
M141 (n38 n20 j65 0) nmos_rvt l=20n nfin=3
M142 (j65 n37 0 0) nmos_rvt l=20n nfin=3
M143 (n38 n20 vdd vdd) pmos_rvt l=20n nfin=6
M144 (n38 n37 vdd vdd) pmos_rvt l=20n nfin=6
M145 (n39 n38 0 0) nmos_rvt l=20n nfin=3
M146 (n39 n38 vdd vdd) pmos_rvt l=20n nfin=6
VS0 (src0 0) vsource type=pwl wave=[0 0.9 3e-10 0.9 3.05e-10 0 6e-10 0 6.05e-10 0.9 9e-10 0.9 9.05e-10 0 1.2e-09 0 1.205e-09 0.9 1.8e-09 0.9 1.805e-09 0 3e-09 0 3.005e-09 0.9 3.6e-09 0.9 3.605e-09 0 3.9e-09 0 3.905e-09 0.9 6.3e-09 0.9 6.305e-09 0 6.9e-09 0 6.905e-09 0.9 7.2e-09 0.9 7.205e-09 0 7.5e-09 0 7.505e-09 0.9 7.8e-09 0.9 7.805e-09 0 8.4e-09 0 8.405e-09 0.9 9e-09 0.9 9.005e-09 0 9.9e-09 0 9.905e-09 0.9 1.02e-08 0.9 1.0205e-08 0 1.05e-08 0 1.0505e-08 0.9 1.11e-08 0.9 1.1105e-08 0 1.14e-08 0 1.1405e-08 0.9 1.17e-08 0.9 1.1705e-08 0 1.2e-08 0 1.2005e-08 0.9 1.23e-08 0.9 1.2305e-08 0 1.26e-08 0 1.2605e-08 0.9 1.29e-08 0.9 1.2905e-08 0 1.32e-08 0 1.3205e-08 0.9 1.35e-08 0.9 1.3505e-08 0 1.38e-08 0 1.3805e-08 0.9 1.41e-08 0.9 1.4105e-08 0 1.44e-08 0 1.4405e-08 0.9 1.47e-08 0.9 1.4705e-08 0 1.5e-08 0 1.5005e-08 0.9 1.53e-08 0.9 1.5305e-08 0 1.56e-08 0 1.5605e-08 0.9 1.59e-08 0.9 1.5905e-08 0 1.65e-08 0 1.6505e-08 0.9 1.68e-08 0.9 1.6805e-08 0 1.71e-08 0 1.7105e-08 0.9 1.77e-08 0.9 1.7705e-08 0 1.83e-08 0 1.8305e-08 0.9 1.86e-08 0.9 1.8605e-08 0 1.89e-08 0 1.8905e-08 0.9 1.92e-08 0.9 1.9205e-08 0 1.95e-08 0 1.9505e-08 0.9 1.98e-08 0.9 1.9805e-08 0 2.01e-08 0 2.0105e-08 0.9 2.04e-08 0.9 2.0405e-08 0 2.19e-08 0 2.1905e-08 0.9 2.22e-08 0.9 2.2205e-08 0 2.25e-08 0 2.2505e-08 0.9 2.28e-08 0.9 2.2805e-08 0 2.31e-08 0 2.3105e-08 0.9 2.34e-08 0.9 2.3405e-08 0 2.37e-08 0 2.3705e-08 0.9 2.4e-08 0.9 2.4005e-08 0 2.43e-08 0 2.4305e-08 0.9 2.49e-08 0.9 2.4905e-08 0 2.55e-08 0 2.5505e-08 0.9 2.58e-08 0.9 2.5805e-08 0 2.61e-08 0 2.6105e-08 0.9 2.64e-08 0.9 2.6405e-08 0 2.67e-08 0 2.6705e-08 0.9 2.7e-08 0.9 2.7005e-08 0 2.76e-08 0 2.7605e-08 0.9 2.79e-08 0.9 2.7905e-08 0 2.82e-08 0 2.8205e-08 0.9 2.85e-08 0.9 2.8505e-08 0 3e-08 0 3.0005e-08 0.9 3.09e-08 0.9 3.0905e-08 0 3.24e-08 0 3.2405e-08 0.9 3.3e-08 0.9 3.3005e-08 0 3.48e-08 0 3.4805e-08 0.9 3.51e-08 0.9 3.5105e-08 0 3.6e-08 0 3.6005e-08 0.9 3.63e-08 0.9 3.6305e-08 0 3.66e-08 0 3.6605e-08 0.9 3.69e-08 0.9 3.6905e-08 0 3.75e-08 0 3.7505e-08 0.9 3.78e-08 0.9 3.7805e-08 0 3.81e-08 0 3.8105e-08 0.9 3.87e-08 0.9 3.8705e-08 0 3.9e-08 0 3.9005e-08 0.9 3.96e-08 0.9 3.9605e-08 0 4.08e-08 0 4.0805e-08 0.9 4.11e-08 0.9 4.1105e-08 0 4.17e-08 0 4.1705e-08 0.9 4.2e-08 0.9 4.2005e-08 0 4.41e-08 0 4.4105e-08 0.9 4.47e-08 0.9 4.4705e-08 0 4.74e-08 0 4.7405e-08 0.9 4.77e-08 0.9 4.7705e-08 0 4.92e-08 0 4.9205e-08 0.9 4.95e-08 0.9 4.9505e-08 0 5.01e-08 0 5.0105e-08 0.9 5.04e-08 0.9 5.0405e-08 0 5.16e-08 0 5.1605e-08 0.9 5.25e-08 0.9 5.2505e-08 0 5.37e-08 0 5.3705e-08 0.9 5.4e-08 0.9 5.4005e-08 0 5.49e-08 0 5.4905e-08 0.9 5.52e-08 0.9 5.5205e-08 0 5.64e-08 0 5.6405e-08 0.9 5.67e-08 0.9 5.6705e-08 0 5.82e-08 0 5.8205e-08 0.9 5.91e-08 0.9 5.9105e-08 0 6.03e-08 0 6.0305e-08 0.9 6.06e-08 0.9 6.0605e-08 0]
MDN0 (i0 src0 0 0) nmos_rvt l=20n nfin=1
MDP0 (i0 src0 vdd vdd) pmos_rvt l=20n nfin=2
VS1 (src1 0) vsource type=pwl wave=[0 0.9 9e-10 0.9 9.05e-10 0 1.2e-09 0 1.205e-09 0.9 1.8e-09 0.9 1.805e-09 0 2.4e-09 0 2.405e-09 0.9 2.7e-09 0.9 2.705e-09 0 3e-09 0 3.005e-09 0.9 6.6e-09 0.9 6.605e-09 0 6.9e-09 0 6.905e-09 0.9 7.8e-09 0.9 7.805e-09 0 8.1e-09 0 8.105e-09 0.9 9e-09 0.9 9.005e-09 0 9.9e-09 0 9.905e-09 0.9 1.11e-08 0.9 1.1105e-08 0 1.14e-08 0 1.1405e-08 0.9 1.29e-08 0.9 1.2905e-08 0 1.32e-08 0 1.3205e-08 0.9 1.41e-08 0.9 1.4105e-08 0 1.44e-08 0 1.4405e-08 0.9 1.68e-08 0.9 1.6805e-08 0 1.71e-08 0 1.7105e-08 0.9 1.77e-08 0.9 1.7705e-08 0 1.8e-08 0 1.8005e-08 0.9 1.86e-08 0.9 1.8605e-08 0 1.89e-08 0 1.8905e-08 0.9 1.98e-08 0.9 1.9805e-08 0 2.01e-08 0 2.0105e-08 0.9 2.07e-08 0.9 2.0705e-08 0 2.1e-08 0 2.1005e-08 0.9 2.13e-08 0.9 2.1305e-08 0 2.16e-08 0 2.1605e-08 0.9 2.28e-08 0.9 2.2805e-08 0 2.31e-08 0 2.3105e-08 0.9 2.34e-08 0.9 2.3405e-08 0 2.37e-08 0 2.3705e-08 0.9 2.4e-08 0.9 2.4005e-08 0 2.43e-08 0 2.4305e-08 0.9 2.91e-08 0.9 2.9105e-08 0 2.97e-08 0 2.9705e-08 0.9 3.33e-08 0.9 3.3305e-08 0 3.36e-08 0 3.3605e-08 0.9 3.39e-08 0.9 3.3905e-08 0 3.45e-08 0 3.4505e-08 0.9 3.54e-08 0.9 3.5405e-08 0 3.57e-08 0 3.5705e-08 0.9 3.72e-08 0.9 3.7205e-08 0 3.75e-08 0 3.7505e-08 0.9 3.96e-08 0.9 3.9605e-08 0 3.99e-08 0 3.9905e-08 0.9 4.2e-08 0.9 4.2005e-08 0 4.23e-08 0 4.2305e-08 0.9 4.5e-08 0.9 4.5005e-08 0 4.56e-08 0 4.5605e-08 0.9 4.65e-08 0.9 4.6505e-08 0 4.68e-08 0 4.6805e-08 0.9 4.77e-08 0.9 4.7705e-08 0 4.83e-08 0 4.8305e-08 0.9 4.89e-08 0.9 4.8905e-08 0 4.92e-08 0 4.9205e-08 0.9 4.95e-08 0.9 4.9505e-08 0 4.98e-08 0 4.9805e-08 0.9 5.04e-08 0.9 5.0405e-08 0 5.07e-08 0 5.0705e-08 0.9 5.13e-08 0.9 5.1305e-08 0 5.16e-08 0 5.1605e-08 0.9 5.25e-08 0.9 5.2505e-08 0 5.37e-08 0 5.3705e-08 0.9 5.4e-08 0.9 5.4005e-08 0 5.49e-08 0 5.4905e-08 0.9 5.52e-08 0.9 5.5205e-08 0 5.61e-08 0 5.6105e-08 0.9 5.67e-08 0.9 5.6705e-08 0 5.7e-08 0 5.7005e-08 0.9 5.73e-08 0.9 5.7305e-08 0 5.79e-08 0 5.7905e-08 0.9 5.91e-08 0.9 5.9105e-08 0 6.03e-08 0 6.0305e-08 0.9 6.09e-08 0.9 6.0905e-08 0]
MDN1 (i1 src1 0 0) nmos_rvt l=20n nfin=1
MDP1 (i1 src1 vdd vdd) pmos_rvt l=20n nfin=2
VS2 (src2 0) vsource type=pwl wave=[0 0 4.8e-09 0 4.805e-09 0.9 5.1e-09 0.9 5.105e-09 0 5.4e-09 0 5.405e-09 0.9 5.7e-09 0.9 5.705e-09 0 6e-09 0 6.005e-09 0.9 6.3e-09 0.9 6.305e-09 0 6.6e-09 0 6.605e-09 0.9 6.9e-09 0.9 6.905e-09 0 7.2e-09 0 7.205e-09 0.9 7.5e-09 0.9 7.505e-09 0 7.8e-09 0 7.805e-09 0.9 8.1e-09 0.9 8.105e-09 0 8.4e-09 0 8.405e-09 0.9 8.7e-09 0.9 8.705e-09 0 9e-09 0 9.005e-09 0.9 9.3e-09 0.9 9.305e-09 0 1.11e-08 0 1.1105e-08 0.9 1.14e-08 0.9 1.1405e-08 0 1.17e-08 0 1.1705e-08 0.9 1.2e-08 0.9 1.2005e-08 0 1.23e-08 0 1.2305e-08 0.9 1.26e-08 0.9 1.2605e-08 0 1.29e-08 0 1.2905e-08 0.9 1.32e-08 0.9 1.3205e-08 0 2.07e-08 0 2.0705e-08 0.9 2.1e-08 0.9 2.1005e-08 0 2.13e-08 0 2.1305e-08 0.9 2.19e-08 0.9 2.1905e-08 0 2.22e-08 0 2.2205e-08 0.9 2.25e-08 0.9 2.2505e-08 0 2.28e-08 0 2.2805e-08 0.9 2.31e-08 0.9 2.3105e-08 0 2.34e-08 0 2.3405e-08 0.9 2.37e-08 0.9 2.3705e-08 0 2.4e-08 0 2.4005e-08 0.9 2.43e-08 0.9 2.4305e-08 0 2.49e-08 0 2.4905e-08 0.9 2.52e-08 0.9 2.5205e-08 0 2.55e-08 0 2.5505e-08 0.9 2.58e-08 0.9 2.5805e-08 0 2.61e-08 0 2.6105e-08 0.9 2.67e-08 0.9 2.6705e-08 0 2.73e-08 0 2.7305e-08 0.9 2.76e-08 0.9 2.7605e-08 0 2.85e-08 0 2.8505e-08 0.9 2.88e-08 0.9 2.8805e-08 0 3.03e-08 0 3.0305e-08 0.9 3.06e-08 0.9 3.0605e-08 0 3.21e-08 0 3.2105e-08 0.9 3.24e-08 0.9 3.2405e-08 0 3.27e-08 0 3.2705e-08 0.9 3.3e-08 0.9 3.3005e-08 0 3.39e-08 0 3.3905e-08 0.9 3.45e-08 0.9 3.4505e-08 0 3.48e-08 0 3.4805e-08 0.9 3.51e-08 0.9 3.5105e-08 0 3.66e-08 0 3.6605e-08 0.9 3.69e-08 0.9 3.6905e-08 0 3.72e-08 0 3.7205e-08 0.9 3.75e-08 0.9 3.7505e-08 0 3.84e-08 0 3.8405e-08 0.9 3.9e-08 0.9 3.9005e-08 0 3.93e-08 0 3.9305e-08 0.9 3.99e-08 0.9 3.9905e-08 0 4.02e-08 0 4.0205e-08 0.9 4.05e-08 0.9 4.0505e-08 0 4.23e-08 0 4.2305e-08 0.9 4.26e-08 0.9 4.2605e-08 0 4.29e-08 0 4.2905e-08 0.9 4.35e-08 0.9 4.3505e-08 0 4.38e-08 0 4.3805e-08 0.9 4.41e-08 0.9 4.4105e-08 0 4.56e-08 0 4.5605e-08 0.9 4.59e-08 0.9 4.5905e-08 0 4.71e-08 0 4.7105e-08 0.9 4.74e-08 0.9 4.7405e-08 0 4.77e-08 0 4.7705e-08 0.9 4.8e-08 0.9 4.8005e-08 0 4.98e-08 0 4.9805e-08 0.9 5.04e-08 0.9 5.0405e-08 0 5.13e-08 0 5.1305e-08 0.9 5.16e-08 0.9 5.1605e-08 0 5.31e-08 0 5.3105e-08 0.9 5.34e-08 0.9 5.3405e-08 0 5.55e-08 0 5.5505e-08 0.9 5.58e-08 0.9 5.5805e-08 0 5.67e-08 0 5.6705e-08 0.9 5.73e-08 0.9 5.7305e-08 0 5.85e-08 0 5.8505e-08 0.9 5.88e-08 0.9 5.8805e-08 0 5.94e-08 0 5.9405e-08 0.9 5.97e-08 0.9 5.9705e-08 0 6.12e-08 0 6.1205e-08 0.9 6.15e-08 0.9 6.1505e-08 0]
MDN2 (i2 src2 0 0) nmos_rvt l=20n nfin=1
MDP2 (i2 src2 vdd vdd) pmos_rvt l=20n nfin=2
VS3 (src3 0) vsource type=pwl wave=[0 0.9 3e-10 0.9 3.05e-10 0 6e-10 0 6.05e-10 0.9 9e-10 0.9 9.05e-10 0 1.2e-09 0 1.205e-09 0.9 1.5e-09 0.9 1.505e-09 0 1.8e-09 0 1.805e-09 0.9 2.1e-09 0.9 2.105e-09 0 2.4e-09 0 2.405e-09 0.9 2.7e-09 0.9 2.705e-09 0 3e-09 0 3.005e-09 0.9 3.3e-09 0.9 3.305e-09 0 3.6e-09 0 3.605e-09 0.9 3.9e-09 0.9 3.905e-09 0 4.2e-09 0 4.205e-09 0.9 4.5e-09 0.9 4.505e-09 0 4.8e-09 0 4.805e-09 0.9 5.1e-09 0.9 5.105e-09 0 5.4e-09 0 5.405e-09 0.9 5.7e-09 0.9 5.705e-09 0 6e-09 0 6.005e-09 0.9 6.3e-09 0.9 6.305e-09 0 6.6e-09 0 6.605e-09 0.9 6.9e-09 0.9 6.905e-09 0 7.2e-09 0 7.205e-09 0.9 7.5e-09 0.9 7.505e-09 0 7.8e-09 0 7.805e-09 0.9 8.1e-09 0.9 8.105e-09 0 8.4e-09 0 8.405e-09 0.9 8.7e-09 0.9 8.705e-09 0 9e-09 0 9.005e-09 0.9 9.3e-09 0.9 9.305e-09 0 9.9e-09 0 9.905e-09 0.9 1.02e-08 0.9 1.0205e-08 0 1.05e-08 0 1.0505e-08 0.9 1.08e-08 0.9 1.0805e-08 0 1.11e-08 0 1.1105e-08 0.9 1.14e-08 0.9 1.1405e-08 0 1.17e-08 0 1.1705e-08 0.9 1.35e-08 0.9 1.3505e-08 0 1.38e-08 0 1.3805e-08 0.9 1.41e-08 0.9 1.4105e-08 0 1.47e-08 0 1.4705e-08 0.9 1.5e-08 0.9 1.5005e-08 0 1.53e-08 0 1.5305e-08 0.9 1.56e-08 0.9 1.5605e-08 0 1.59e-08 0 1.5905e-08 0.9 1.62e-08 0.9 1.6205e-08 0 1.65e-08 0 1.6505e-08 0.9 1.68e-08 0.9 1.6805e-08 0 1.71e-08 0 1.7105e-08 0.9 1.74e-08 0.9 1.7405e-08 0 1.77e-08 0 1.7705e-08 0.9 1.83e-08 0.9 1.8305e-08 0 1.86e-08 0 1.8605e-08 0.9 1.89e-08 0.9 1.8905e-08 0 1.95e-08 0 1.9505e-08 0.9 1.98e-08 0.9 1.9805e-08 0 2.01e-08 0 2.0105e-08 0.9 2.1e-08 0.9 2.1005e-08 0 2.13e-08 0 2.1305e-08 0.9 2.19e-08 0.9 2.1905e-08 0 2.22e-08 0 2.2205e-08 0.9 2.31e-08 0.9 2.3105e-08 0 2.34e-08 0 2.3405e-08 0.9 2.37e-08 0.9 2.3705e-08 0 2.4e-08 0 2.4005e-08 0.9 2.52e-08 0.9 2.5205e-08 0 2.55e-08 0 2.5505e-08 0.9 2.76e-08 0.9 2.7605e-08 0 2.79e-08 0 2.7905e-08 0.9 2.88e-08 0.9 2.8805e-08 0 2.91e-08 0 2.9105e-08 0.9 2.97e-08 0.9 2.9705e-08 0 3.03e-08 0 3.0305e-08 0.9 3.06e-08 0.9 3.0605e-08 0 3.09e-08 0 3.0905e-08 0.9 3.15e-08 0.9 3.1505e-08 0 3.18e-08 0 3.1805e-08 0.9 3.24e-08 0.9 3.2405e-08 0 3.27e-08 0 3.2705e-08 0.9 3.3e-08 0.9 3.3005e-08 0 3.33e-08 0 3.3305e-08 0.9 3.54e-08 0.9 3.5405e-08 0 3.6e-08 0 3.6005e-08 0.9 3.63e-08 0.9 3.6305e-08 0 3.66e-08 0 3.6605e-08 0.9 3.78e-08 0.9 3.7805e-08 0 3.81e-08 0 3.8105e-08 0.9 4.2e-08 0.9 4.2005e-08 0 4.23e-08 0 4.2305e-08 0.9 4.26e-08 0.9 4.2605e-08 0 4.29e-08 0 4.2905e-08 0.9 4.35e-08 0.9 4.3505e-08 0 4.38e-08 0 4.3805e-08 0.9 4.53e-08 0.9 4.5305e-08 0 4.56e-08 0 4.5605e-08 0.9 4.59e-08 0.9 4.5905e-08 0 4.71e-08 0 4.7105e-08 0.9 4.8e-08 0.9 4.8005e-08 0 4.86e-08 0 4.8605e-08 0.9 4.89e-08 0.9 4.8905e-08 0 4.98e-08 0 4.9805e-08 0.9 5.04e-08 0.9 5.0405e-08 0 5.13e-08 0 5.1305e-08 0.9 5.16e-08 0.9 5.1605e-08 0 5.19e-08 0 5.1905e-08 0.9 5.25e-08 0.9 5.2505e-08 0 5.28e-08 0 5.2805e-08 0.9 5.43e-08 0.9 5.4305e-08 0 5.46e-08 0 5.4605e-08 0.9 5.49e-08 0.9 5.4905e-08 0 5.52e-08 0 5.5205e-08 0.9 5.61e-08 0.9 5.6105e-08 0 5.64e-08 0 5.6405e-08 0.9 5.73e-08 0.9 5.7305e-08 0 5.85e-08 0 5.8505e-08 0.9 5.88e-08 0.9 5.8805e-08 0 5.94e-08 0 5.9405e-08 0.9 5.97e-08 0.9 5.9705e-08 0 6.03e-08 0 6.0305e-08 0.9 6.09e-08 0.9 6.0905e-08 0 6.12e-08 0 6.1205e-08 0.9 6.15e-08 0.9 6.1505e-08 0]
MDN3 (i3 src3 0 0) nmos_rvt l=20n nfin=1
MDP3 (i3 src3 vdd vdd) pmos_rvt l=20n nfin=2
VS4 (src4 0) vsource type=pwl wave=[0 0.9 1.2e-09 0.9 1.205e-09 0 1.8e-09 0 1.805e-09 0.9 3e-09 0.9 3.005e-09 0 3.6e-09 0 3.605e-09 0.9 4.8e-09 0.9 4.805e-09 0 6e-09 0 6.005e-09 0.9 9.6e-09 0.9 9.605e-09 0 1.08e-08 0 1.0805e-08 0.9 1.32e-08 0.9 1.3205e-08 0 1.56e-08 0 1.5605e-08 0.9 1.74e-08 0.9 1.7405e-08 0 2.46e-08 0 2.4605e-08 0.9 2.52e-08 0.9 2.5205e-08 0 2.64e-08 0 2.6405e-08 0.9 3.36e-08 0.9 3.3605e-08 0]
MDN4 (i4 src4 0 0) nmos_rvt l=20n nfin=1
MDP4 (i4 src4 vdd vdd) pmos_rvt l=20n nfin=2
VS5 (src5 0) vsource type=pwl wave=[0 0.9 1.2e-09 0.9 1.205e-09 0 1.8e-09 0 1.805e-09 0.9 4.8e-09 0.9 4.805e-09 0 5.4e-09 0 5.405e-09 0.9 9.6e-09 0.9 9.605e-09 0 1.02e-08 0 1.0205e-08 0.9 1.38e-08 0.9 1.3805e-08 0 1.44e-08 0 1.4405e-08 0.9 1.74e-08 0.9 1.7405e-08 0 1.8e-08 0 1.8005e-08 0.9 1.86e-08 0.9 1.8605e-08 0 1.92e-08 0 1.9205e-08 0.9 1.98e-08 0.9 1.9805e-08 0 2.28e-08 0 2.2805e-08 0.9 2.34e-08 0.9 2.3405e-08 0 2.4e-08 0 2.4005e-08 0.9 2.52e-08 0.9 2.5205e-08 0 2.64e-08 0 2.6405e-08 0.9 4.74e-08 0.9 4.7405e-08 0]
MDN5 (i5 src5 0 0) nmos_rvt l=20n nfin=1
MDP5 (i5 src5 vdd vdd) pmos_rvt l=20n nfin=2
VS6 (src6 0) vsource type=pwl wave=[0 0 2.16e-08 0 2.1605e-08 0.9 2.46e-08 0.9 2.4605e-08 0 2.52e-08 0 2.5205e-08 0.9 2.64e-08 0.9 2.6405e-08 0 3.36e-08 0 3.3605e-08 0.9 3.66e-08 0.9 3.6605e-08 0 4.74e-08 0 4.7405e-08 0.9 5.1e-08 0.9 5.1005e-08 0]
MDN6 (i6 src6 0 0) nmos_rvt l=20n nfin=1
MDP6 (i6 src6 vdd vdd) pmos_rvt l=20n nfin=2
VS7 (src7 0) vsource type=pwl wave=[0 0 1.2e-08 0 1.2005e-08 0.9 1.32e-08 0.9 1.3205e-08 0 1.92e-08 0 1.9205e-08 0.9 2.1e-08 0.9 2.1005e-08 0 2.16e-08 0 2.1605e-08 0.9 2.46e-08 0.9 2.4605e-08 0 2.52e-08 0 2.5205e-08 0.9 3e-08 0.9 3.0005e-08 0 3.36e-08 0 3.3605e-08 0.9 4.2e-08 0.9 4.2005e-08 0 4.74e-08 0 4.7405e-08 0.9 5.64e-08 0.9 5.6405e-08 0]
MDN7 (i7 src7 0 0) nmos_rvt l=20n nfin=1
MDP7 (i7 src7 vdd vdd) pmos_rvt l=20n nfin=2
VS8 (src8 0) vsource type=pwl wave=[0 0 4.8e-09 0 4.805e-09 0.9 9.6e-09 0.9 9.605e-09 0 1.08e-08 0 1.0805e-08 0.9 1.32e-08 0.9 1.3205e-08 0 1.44e-08 0 1.4405e-08 0.9 1.5e-08 0.9 1.5005e-08 0 2.64e-08 0 2.6405e-08 0.9 2.82e-08 0.9 2.8205e-08 0 3e-08 0 3.0005e-08 0.9 3.18e-08 0.9 3.1805e-08 0 3.36e-08 0 3.3605e-08 0.9 3.54e-08 0.9 3.5405e-08 0 3.66e-08 0 3.6605e-08 0.9 3.84e-08 0.9 3.8405e-08 0 4.2e-08 0 4.2005e-08 0.9 4.38e-08 0.9 4.3805e-08 0 4.74e-08 0 4.7405e-08 0.9 4.92e-08 0.9 4.9205e-08 0 5.1e-08 0 5.1005e-08 0.9 5.28e-08 0.9 5.2805e-08 0 5.64e-08 0 5.6405e-08 0.9 5.82e-08 0.9 5.8205e-08 0]
MDN8 (i8 src8 0 0) nmos_rvt l=20n nfin=1
MDP8 (i8 src8 vdd vdd) pmos_rvt l=20n nfin=2
VS9 (src9 0) vsource type=pwl wave=[0 0.9 4.02e-08 0.9 4.0205e-08 0 4.2e-08 0 4.2005e-08 0.9 4.56e-08 0.9 4.5605e-08 0 4.74e-08 0 4.7405e-08 0.9 5.46e-08 0.9 5.4605e-08 0 5.64e-08 0 5.6405e-08 0.9 6e-08 0.9 6.0005e-08 0]
MDN9 (i9 src9 0 0) nmos_rvt l=20n nfin=1
MDP9 (i9 src9 vdd vdd) pmos_rvt l=20n nfin=2
CL0 (n35 0) capacitor c=1f
CL1 (n39 0) capacitor c=1f
tran tran stop=6.18e-08 maxstep=5p errpreset=conservative
save i0 i1 i2 i3 i4 i5 i6 i7 i8 i9 n35 n39 VDD:p
