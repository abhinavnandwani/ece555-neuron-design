simulator lang=spectre
simulatorOptions options temp=25
simulator lang=spice
.include 'asap7_TT.pm'
simulator lang=spectre
VDD (vdd 0) vsource dc=0.9
M1 (n0 i0 j1 0) nmos_rvt l=20n nfin=2
M2 (j1 i4 0 0) nmos_rvt l=20n nfin=2
M3 (n0 i0 vdd vdd) pmos_rvt l=20n nfin=3
M4 (n0 i4 vdd vdd) pmos_rvt l=20n nfin=3
M5 (n1 n0 0 0) nmos_rvt l=20n nfin=2
M6 (n1 n0 vdd vdd) pmos_rvt l=20n nfin=3
M7 (n2 i1 j3 0) nmos_rvt l=20n nfin=2
M8 (j3 i5 0 0) nmos_rvt l=20n nfin=2
M9 (n2 i1 vdd vdd) pmos_rvt l=20n nfin=3
M10 (n2 i5 vdd vdd) pmos_rvt l=20n nfin=3
M11 (n3 i1 j5 0) nmos_rvt l=20n nfin=2
M12 (n3 i5 j5 0) nmos_rvt l=20n nfin=2
M13 (j5 n2 0 0) nmos_rvt l=20n nfin=2
M14 (n3 i1 j7 vdd) pmos_rvt l=20n nfin=3
M15 (j7 i5 vdd vdd) pmos_rvt l=20n nfin=3
M16 (n3 n2 vdd vdd) pmos_rvt l=20n nfin=3
M17 (n4 n0 0 0) nmos_rvt l=20n nfin=2
M18 (n4 n3 0 0) nmos_rvt l=20n nfin=2
M19 (n4 n0 j9 vdd) pmos_rvt l=20n nfin=3
M20 (j9 n3 vdd vdd) pmos_rvt l=20n nfin=3
M21 (n5 i2 j11 0) nmos_rvt l=20n nfin=2
M22 (j11 i6 0 0) nmos_rvt l=20n nfin=2
M23 (n5 i2 vdd vdd) pmos_rvt l=20n nfin=3
M24 (n5 i6 vdd vdd) pmos_rvt l=20n nfin=3
M25 (n6 n5 0 0) nmos_rvt l=20n nfin=2
M26 (n6 n5 vdd vdd) pmos_rvt l=20n nfin=3
M27 (n7 i3 j13 0) nmos_rvt l=20n nfin=2
M28 (j13 i7 0 0) nmos_rvt l=20n nfin=2
M29 (n7 i3 vdd vdd) pmos_rvt l=20n nfin=3
M30 (n7 i7 vdd vdd) pmos_rvt l=20n nfin=3
M31 (n8 i3 j15 0) nmos_rvt l=20n nfin=2
M32 (n8 i7 j15 0) nmos_rvt l=20n nfin=2
M33 (j15 n7 0 0) nmos_rvt l=20n nfin=2
M34 (n8 i3 j17 vdd) pmos_rvt l=20n nfin=3
M35 (j17 i7 vdd vdd) pmos_rvt l=20n nfin=3
M36 (n8 n7 vdd vdd) pmos_rvt l=20n nfin=3
M37 (n9 n5 0 0) nmos_rvt l=20n nfin=2
M38 (n9 n8 0 0) nmos_rvt l=20n nfin=2
M39 (n9 n5 j19 vdd) pmos_rvt l=20n nfin=3
M40 (j19 n8 vdd vdd) pmos_rvt l=20n nfin=3
M41 (n10 n1 j21 0) nmos_rvt l=20n nfin=2
M42 (j21 n6 0 0) nmos_rvt l=20n nfin=2
M43 (n10 i8 j23 0) nmos_rvt l=20n nfin=2
M44 (j23 n1 0 0) nmos_rvt l=20n nfin=2
M45 (j23 n6 0 0) nmos_rvt l=20n nfin=2
M46 (n10 n1 j25 vdd) pmos_rvt l=20n nfin=3
M47 (n10 n6 j25 vdd) pmos_rvt l=20n nfin=3
M48 (j25 i8 vdd vdd) pmos_rvt l=20n nfin=3
M49 (j25 n1 j27 vdd) pmos_rvt l=20n nfin=3
M50 (j27 n6 vdd vdd) pmos_rvt l=20n nfin=3
M51 (n11 n1 j29 0) nmos_rvt l=20n nfin=2
M52 (j29 n6 j30 0) nmos_rvt l=20n nfin=2
M53 (j30 i8 0 0) nmos_rvt l=20n nfin=2
M54 (n11 n10 j32 0) nmos_rvt l=20n nfin=2
M55 (j32 n1 0 0) nmos_rvt l=20n nfin=2
M56 (j32 n6 0 0) nmos_rvt l=20n nfin=2
M57 (j32 i8 0 0) nmos_rvt l=20n nfin=2
M58 (n11 n1 j34 vdd) pmos_rvt l=20n nfin=3
M59 (n11 n6 j34 vdd) pmos_rvt l=20n nfin=3
M60 (n11 i8 j34 vdd) pmos_rvt l=20n nfin=3
M61 (j34 n10 vdd vdd) pmos_rvt l=20n nfin=3
M62 (j34 n1 j36 vdd) pmos_rvt l=20n nfin=3
M63 (j36 n6 j37 vdd) pmos_rvt l=20n nfin=3
M64 (j37 i8 vdd vdd) pmos_rvt l=20n nfin=3
M65 (n14 n4 j39 0) nmos_rvt l=20n nfin=2
M66 (j39 n9 0 0) nmos_rvt l=20n nfin=2
M67 (n14 i9 j41 0) nmos_rvt l=20n nfin=2
M68 (j41 n4 0 0) nmos_rvt l=20n nfin=2
M69 (j41 n9 0 0) nmos_rvt l=20n nfin=2
M70 (n14 n4 j43 vdd) pmos_rvt l=20n nfin=3
M71 (n14 n9 j43 vdd) pmos_rvt l=20n nfin=3
M72 (j43 i9 vdd vdd) pmos_rvt l=20n nfin=3
M73 (j43 n4 j45 vdd) pmos_rvt l=20n nfin=3
M74 (j45 n9 vdd vdd) pmos_rvt l=20n nfin=3
M75 (n15 n4 j47 0) nmos_rvt l=20n nfin=2
M76 (j47 n9 j48 0) nmos_rvt l=20n nfin=2
M77 (j48 i9 0 0) nmos_rvt l=20n nfin=2
M78 (n15 n14 j50 0) nmos_rvt l=20n nfin=2
M79 (j50 n4 0 0) nmos_rvt l=20n nfin=2
M80 (j50 n9 0 0) nmos_rvt l=20n nfin=2
M81 (j50 i9 0 0) nmos_rvt l=20n nfin=2
M82 (n15 n4 j52 vdd) pmos_rvt l=20n nfin=3
M83 (n15 n9 j52 vdd) pmos_rvt l=20n nfin=3
M84 (n15 i9 j52 vdd) pmos_rvt l=20n nfin=3
M85 (j52 n14 vdd vdd) pmos_rvt l=20n nfin=3
M86 (j52 n4 j54 vdd) pmos_rvt l=20n nfin=3
M87 (j54 n9 j55 vdd) pmos_rvt l=20n nfin=3
M88 (j55 i9 vdd vdd) pmos_rvt l=20n nfin=3
M89 (n16 n15 0 0) nmos_rvt l=20n nfin=2
M90 (n16 n15 vdd vdd) pmos_rvt l=20n nfin=3
M91 (n17 n14 0 0) nmos_rvt l=20n nfin=2
M92 (n17 n14 vdd vdd) pmos_rvt l=20n nfin=3
M93 (n18 n10 j57 0) nmos_rvt l=20n nfin=2
M94 (j57 n16 0 0) nmos_rvt l=20n nfin=2
M95 (n18 n11 0 0) nmos_rvt l=20n nfin=2
M96 (n18 n17 0 0) nmos_rvt l=20n nfin=2
M97 (n18 n10 j59 vdd) pmos_rvt l=20n nfin=3
M98 (n18 n16 j59 vdd) pmos_rvt l=20n nfin=3
M99 (j59 n11 j60 vdd) pmos_rvt l=20n nfin=3
M100 (j60 n17 vdd vdd) pmos_rvt l=20n nfin=3
M101 (n19 n10 0 0) nmos_rvt l=20n nfin=2
M102 (n19 n16 0 0) nmos_rvt l=20n nfin=2
M103 (n19 n17 0 0) nmos_rvt l=20n nfin=2
M104 (n19 n10 j62 vdd) pmos_rvt l=20n nfin=3
M105 (j62 n16 j63 vdd) pmos_rvt l=20n nfin=3
M106 (j63 n17 vdd vdd) pmos_rvt l=20n nfin=3
VS0 (src0 0) vsource type=pwl wave=[0 0.9 3e-10 0.9 3.05e-10 0 3.6e-09 0 3.605e-09 0.9 3.9e-09 0.9 3.905e-09 0 4.2e-09 0 4.205e-09 0.9 4.5e-09 0.9 4.505e-09 0 4.8e-09 0 4.805e-09 0.9 5.1e-09 0.9 5.105e-09 0 7.8e-09 0 7.805e-09 0.9 8.1e-09 0.9 8.105e-09 0 8.4e-09 0 8.405e-09 0.9 8.7e-09 0.9 8.705e-09 0 9e-09 0 9.005e-09 0.9 9.3e-09 0.9 9.305e-09 0 1.14e-08 0 1.1405e-08 0.9 1.17e-08 0.9 1.1705e-08 0 1.2e-08 0 1.2005e-08 0.9 1.23e-08 0.9 1.2305e-08 0 1.26e-08 0 1.2605e-08 0.9 1.29e-08 0.9 1.2905e-08 0 1.44e-08 0 1.4405e-08 0.9 1.47e-08 0.9 1.4705e-08 0 1.5e-08 0 1.5005e-08 0.9 1.53e-08 0.9 1.5305e-08 0 1.56e-08 0 1.5605e-08 0.9 1.59e-08 0.9 1.5905e-08 0 1.68e-08 0 1.6805e-08 0.9 1.71e-08 0.9 1.7105e-08 0 1.74e-08 0 1.7405e-08 0.9 1.77e-08 0.9 1.7705e-08 0 1.8e-08 0 1.8005e-08 0.9 1.83e-08 0.9 1.8305e-08 0 1.86e-08 0 1.8605e-08 0.9 1.89e-08 0.9 1.8905e-08 0 1.92e-08 0 1.9205e-08 0.9 1.95e-08 0.9 1.9505e-08 0 1.98e-08 0 1.9805e-08 0.9 2.22e-08 0.9 2.2205e-08 0 2.55e-08 0 2.5505e-08 0.9 2.58e-08 0.9 2.5805e-08 0 2.61e-08 0 2.6105e-08 0.9 2.64e-08 0.9 2.6405e-08 0 2.67e-08 0 2.6705e-08 0.9 2.7e-08 0.9 2.7005e-08 0 2.97e-08 0 2.9705e-08 0.9 3e-08 0.9 3.0005e-08 0 3.03e-08 0 3.0305e-08 0.9 3.06e-08 0.9 3.0605e-08 0 3.09e-08 0 3.0905e-08 0.9 3.12e-08 0.9 3.1205e-08 0 3.33e-08 0 3.3305e-08 0.9 3.36e-08 0.9 3.3605e-08 0 3.39e-08 0 3.3905e-08 0.9 3.42e-08 0.9 3.4205e-08 0 3.45e-08 0 3.4505e-08 0.9 3.48e-08 0.9 3.4805e-08 0 3.63e-08 0 3.6305e-08 0.9 3.66e-08 0.9 3.6605e-08 0 3.69e-08 0 3.6905e-08 0.9 3.72e-08 0.9 3.7205e-08 0 3.75e-08 0 3.7505e-08 0.9 3.78e-08 0.9 3.7805e-08 0 3.87e-08 0 3.8705e-08 0.9 3.9e-08 0.9 3.9005e-08 0 3.93e-08 0 3.9305e-08 0.9 3.96e-08 0.9 3.9605e-08 0 3.99e-08 0 3.9905e-08 0.9 4.02e-08 0.9 4.0205e-08 0 4.05e-08 0 4.0505e-08 0.9 4.08e-08 0.9 4.0805e-08 0 4.11e-08 0 4.1105e-08 0.9 4.14e-08 0.9 4.1405e-08 0 4.17e-08 0 4.1705e-08 0.9 4.41e-08 0.9 4.4105e-08 0 4.74e-08 0 4.7405e-08 0.9 4.77e-08 0.9 4.7705e-08 0 4.8e-08 0 4.8005e-08 0.9 4.83e-08 0.9 4.8305e-08 0 4.86e-08 0 4.8605e-08 0.9 4.89e-08 0.9 4.8905e-08 0 5.16e-08 0 5.1605e-08 0.9 5.19e-08 0.9 5.1905e-08 0 5.22e-08 0 5.2205e-08 0.9 5.25e-08 0.9 5.2505e-08 0 5.28e-08 0 5.2805e-08 0.9 5.31e-08 0.9 5.3105e-08 0 5.52e-08 0 5.5205e-08 0.9 5.55e-08 0.9 5.5505e-08 0 5.58e-08 0 5.5805e-08 0.9 5.61e-08 0.9 5.6105e-08 0 5.64e-08 0 5.6405e-08 0.9 5.67e-08 0.9 5.6705e-08 0 5.82e-08 0 5.8205e-08 0.9 5.85e-08 0.9 5.8505e-08 0 5.88e-08 0 5.8805e-08 0.9 5.91e-08 0.9 5.9105e-08 0 5.94e-08 0 5.9405e-08 0.9 5.97e-08 0.9 5.9705e-08 0 6.06e-08 0 6.0605e-08 0.9 6.09e-08 0.9 6.0905e-08 0 6.12e-08 0 6.1205e-08 0.9 6.15e-08 0.9 6.1505e-08 0 6.18e-08 0 6.1805e-08 0.9 6.21e-08 0.9 6.2105e-08 0 6.24e-08 0 6.2405e-08 0.9 6.27e-08 0.9 6.2705e-08 0 6.3e-08 0 6.3005e-08 0.9 6.33e-08 0.9 6.3305e-08 0 6.36e-08 0 6.3605e-08 0.9 6.6e-08 0.9 6.6005e-08 0 6.93e-08 0 6.9305e-08 0.9 6.96e-08 0.9 6.9605e-08 0 6.99e-08 0 6.9905e-08 0.9 7.02e-08 0.9 7.0205e-08 0 7.05e-08 0 7.0505e-08 0.9 7.08e-08 0.9 7.0805e-08 0 7.35e-08 0 7.3505e-08 0.9 7.38e-08 0.9 7.3805e-08 0 7.41e-08 0 7.4105e-08 0.9 7.44e-08 0.9 7.4405e-08 0 7.47e-08 0 7.4705e-08 0.9 7.5e-08 0.9 7.5005e-08 0 7.71e-08 0 7.7105e-08 0.9 7.74e-08 0.9 7.7405e-08 0 7.77e-08 0 7.7705e-08 0.9 7.8e-08 0.9 7.8005e-08 0 7.83e-08 0 7.8305e-08 0.9 7.86e-08 0.9 7.8605e-08 0 8.01e-08 0 8.0105e-08 0.9 8.04e-08 0.9 8.0405e-08 0 8.07e-08 0 8.0705e-08 0.9 8.1e-08 0.9 8.1005e-08 0 8.13e-08 0 8.1305e-08 0.9 8.16e-08 0.9 8.1605e-08 0 8.25e-08 0 8.2505e-08 0.9 8.28e-08 0.9 8.2805e-08 0 8.31e-08 0 8.3105e-08 0.9 8.34e-08 0.9 8.3405e-08 0 8.37e-08 0 8.3705e-08 0.9 8.4e-08 0.9 8.4005e-08 0 8.43e-08 0 8.4305e-08 0.9 8.46e-08 0.9 8.4605e-08 0 8.49e-08 0 8.4905e-08 0.9 8.52e-08 0.9 8.5205e-08 0 8.55e-08 0 8.5505e-08 0.9 8.79e-08 0.9 8.7905e-08 0 9.12e-08 0 9.1205e-08 0.9 9.15e-08 0.9 9.1505e-08 0 9.18e-08 0 9.1805e-08 0.9 9.21e-08 0.9 9.2105e-08 0 9.24e-08 0 9.2405e-08 0.9 9.27e-08 0.9 9.2705e-08 0 9.54e-08 0 9.5405e-08 0.9 9.57e-08 0.9 9.5705e-08 0 9.6e-08 0 9.6005e-08 0.9 9.63e-08 0.9 9.6305e-08 0 9.66e-08 0 9.6605e-08 0.9 9.69e-08 0.9 9.6905e-08 0 9.9e-08 0 9.9005e-08 0.9 9.93e-08 0.9 9.9305e-08 0 9.96e-08 0 9.9605e-08 0.9 9.99e-08 0.9 9.9905e-08 0 1.002e-07 0 1.00205e-07 0.9 1.005e-07 0.9 1.00505e-07 0 1.02e-07 0 1.02005e-07 0.9 1.023e-07 0.9 1.02305e-07 0 1.026e-07 0 1.02605e-07 0.9 1.029e-07 0.9 1.02905e-07 0 1.032e-07 0 1.03205e-07 0.9 1.035e-07 0.9 1.03505e-07 0 1.044e-07 0 1.04405e-07 0.9 1.047e-07 0.9 1.04705e-07 0 1.05e-07 0 1.05005e-07 0.9 1.053e-07 0.9 1.05305e-07 0 1.056e-07 0 1.05605e-07 0.9 1.059e-07 0.9 1.05905e-07 0 1.062e-07 0 1.06205e-07 0.9 1.065e-07 0.9 1.06505e-07 0 1.068e-07 0 1.06805e-07 0.9 1.071e-07 0.9 1.07105e-07 0 1.074e-07 0 1.07405e-07 0.9 1.098e-07 0.9 1.09805e-07 0 1.131e-07 0 1.13105e-07 0.9 1.134e-07 0.9 1.13405e-07 0 1.137e-07 0 1.13705e-07 0.9 1.14e-07 0.9 1.14005e-07 0 1.143e-07 0 1.14305e-07 0.9 1.146e-07 0.9 1.14605e-07 0 1.173e-07 0 1.17305e-07 0.9 1.176e-07 0.9 1.17605e-07 0 1.179e-07 0 1.17905e-07 0.9 1.182e-07 0.9 1.18205e-07 0 1.185e-07 0 1.18505e-07 0.9 1.188e-07 0.9 1.18805e-07 0 1.209e-07 0 1.20905e-07 0.9 1.212e-07 0.9 1.21205e-07 0 1.215e-07 0 1.21505e-07 0.9 1.218e-07 0.9 1.21805e-07 0 1.221e-07 0 1.22105e-07 0.9 1.224e-07 0.9 1.22405e-07 0 1.239e-07 0 1.23905e-07 0.9 1.242e-07 0.9 1.24205e-07 0 1.245e-07 0 1.24505e-07 0.9 1.248e-07 0.9 1.24805e-07 0 1.251e-07 0 1.25105e-07 0.9 1.254e-07 0.9 1.25405e-07 0 1.263e-07 0 1.26305e-07 0.9 1.266e-07 0.9 1.26605e-07 0 1.269e-07 0 1.26905e-07 0.9 1.272e-07 0.9 1.27205e-07 0 1.275e-07 0 1.27505e-07 0.9 1.278e-07 0.9 1.27805e-07 0 1.281e-07 0 1.28105e-07 0.9 1.284e-07 0.9 1.28405e-07 0 1.287e-07 0 1.28705e-07 0.9 1.29e-07 0.9 1.29005e-07 0 1.293e-07 0 1.29305e-07 0.9 1.317e-07 0.9 1.31705e-07 0 1.35e-07 0 1.35005e-07 0.9 1.353e-07 0.9 1.35305e-07 0 1.356e-07 0 1.35605e-07 0.9 1.359e-07 0.9 1.35905e-07 0 1.362e-07 0 1.36205e-07 0.9 1.365e-07 0.9 1.36505e-07 0 1.392e-07 0 1.39205e-07 0.9 1.395e-07 0.9 1.39505e-07 0 1.398e-07 0 1.39805e-07 0.9 1.401e-07 0.9 1.40105e-07 0 1.404e-07 0 1.40405e-07 0.9 1.407e-07 0.9 1.40705e-07 0 1.428e-07 0 1.42805e-07 0.9 1.431e-07 0.9 1.43105e-07 0 1.434e-07 0 1.43405e-07 0.9 1.437e-07 0.9 1.43705e-07 0 1.44e-07 0 1.44005e-07 0.9 1.443e-07 0.9 1.44305e-07 0 1.458e-07 0 1.45805e-07 0.9 1.461e-07 0.9 1.46105e-07 0 1.464e-07 0 1.46405e-07 0.9 1.467e-07 0.9 1.46705e-07 0 1.47e-07 0 1.47005e-07 0.9 1.473e-07 0.9 1.47305e-07 0 1.482e-07 0 1.48205e-07 0.9 1.485e-07 0.9 1.48505e-07 0 1.488e-07 0 1.48805e-07 0.9 1.491e-07 0.9 1.49105e-07 0 1.494e-07 0 1.49405e-07 0.9 1.497e-07 0.9 1.49705e-07 0 1.5e-07 0 1.50005e-07 0.9 1.503e-07 0.9 1.50305e-07 0 1.506e-07 0 1.50605e-07 0.9 1.509e-07 0.9 1.50905e-07 0 1.512e-07 0 1.51205e-07 0.9 1.536e-07 0.9 1.53605e-07 0 1.569e-07 0 1.56905e-07 0.9 1.572e-07 0.9 1.57205e-07 0 1.575e-07 0 1.57505e-07 0.9 1.578e-07 0.9 1.57805e-07 0 1.581e-07 0 1.58105e-07 0.9 1.584e-07 0.9 1.58405e-07 0 1.611e-07 0 1.61105e-07 0.9 1.614e-07 0.9 1.61405e-07 0 1.617e-07 0 1.61705e-07 0.9 1.62e-07 0.9 1.62005e-07 0 1.623e-07 0 1.62305e-07 0.9 1.626e-07 0.9 1.62605e-07 0 1.647e-07 0 1.64705e-07 0.9 1.65e-07 0.9 1.65005e-07 0 1.653e-07 0 1.65305e-07 0.9 1.656e-07 0.9 1.65605e-07 0 1.659e-07 0 1.65905e-07 0.9 1.662e-07 0.9 1.66205e-07 0 1.677e-07 0 1.67705e-07 0.9 1.68e-07 0.9 1.68005e-07 0 1.683e-07 0 1.68305e-07 0.9 1.686e-07 0.9 1.68605e-07 0 1.689e-07 0 1.68905e-07 0.9 1.692e-07 0.9 1.69205e-07 0 1.701e-07 0 1.70105e-07 0.9 1.704e-07 0.9 1.70405e-07 0 1.707e-07 0 1.70705e-07 0.9 1.71e-07 0.9 1.71005e-07 0 1.713e-07 0 1.71305e-07 0.9 1.716e-07 0.9 1.71605e-07 0 1.719e-07 0 1.71905e-07 0.9 1.722e-07 0.9 1.72205e-07 0 1.725e-07 0 1.72505e-07 0.9 1.728e-07 0.9 1.72805e-07 0 1.731e-07 0 1.73105e-07 0.9 1.755e-07 0.9 1.75505e-07 0 1.788e-07 0 1.78805e-07 0.9 1.791e-07 0.9 1.79105e-07 0 1.794e-07 0 1.79405e-07 0.9 1.797e-07 0.9 1.79705e-07 0 1.8e-07 0 1.80005e-07 0.9 1.803e-07 0.9 1.80305e-07 0 1.83e-07 0 1.83005e-07 0.9 1.833e-07 0.9 1.83305e-07 0 1.836e-07 0 1.83605e-07 0.9 1.839e-07 0.9 1.83905e-07 0 1.842e-07 0 1.84205e-07 0.9 1.845e-07 0.9 1.84505e-07 0 1.866e-07 0 1.86605e-07 0.9 1.869e-07 0.9 1.86905e-07 0 1.872e-07 0 1.87205e-07 0.9 1.875e-07 0.9 1.87505e-07 0 1.878e-07 0 1.87805e-07 0.9 1.881e-07 0.9 1.88105e-07 0 1.896e-07 0 1.89605e-07 0.9 1.899e-07 0.9 1.89905e-07 0 1.902e-07 0 1.90205e-07 0.9 1.905e-07 0.9 1.90505e-07 0 1.908e-07 0 1.90805e-07 0.9 1.911e-07 0.9 1.91105e-07 0 1.92e-07 0 1.92005e-07 0.9 1.923e-07 0.9 1.92305e-07 0 1.926e-07 0 1.92605e-07 0.9 1.929e-07 0.9 1.92905e-07 0 1.932e-07 0 1.93205e-07 0.9 1.935e-07 0.9 1.93505e-07 0 1.938e-07 0 1.93805e-07 0.9 1.941e-07 0.9 1.94105e-07 0 1.944e-07 0 1.94405e-07 0.9 1.947e-07 0.9 1.94705e-07 0 1.95e-07 0 1.95005e-07 0.9 1.974e-07 0.9 1.97405e-07 0 2.007e-07 0 2.00705e-07 0.9 2.01e-07 0.9 2.01005e-07 0 2.013e-07 0 2.01305e-07 0.9 2.016e-07 0.9 2.01605e-07 0 2.019e-07 0 2.01905e-07 0.9 2.022e-07 0.9 2.02205e-07 0 2.049e-07 0 2.04905e-07 0.9 2.052e-07 0.9 2.05205e-07 0 2.055e-07 0 2.05505e-07 0.9 2.058e-07 0.9 2.05805e-07 0 2.061e-07 0 2.06105e-07 0.9 2.064e-07 0.9 2.06405e-07 0 2.085e-07 0 2.08505e-07 0.9 2.088e-07 0.9 2.08805e-07 0 2.091e-07 0 2.09105e-07 0.9 2.094e-07 0.9 2.09405e-07 0 2.097e-07 0 2.09705e-07 0.9 2.1e-07 0.9 2.10005e-07 0 2.115e-07 0 2.11505e-07 0.9 2.118e-07 0.9 2.11805e-07 0 2.121e-07 0 2.12105e-07 0.9 2.124e-07 0.9 2.12405e-07 0 2.127e-07 0 2.12705e-07 0.9 2.13e-07 0.9 2.13005e-07 0 2.139e-07 0 2.13905e-07 0.9 2.142e-07 0.9 2.14205e-07 0 2.145e-07 0 2.14505e-07 0.9 2.148e-07 0.9 2.14805e-07 0 2.151e-07 0 2.15105e-07 0.9 2.154e-07 0.9 2.15405e-07 0 2.157e-07 0 2.15705e-07 0.9 2.16e-07 0.9 2.16005e-07 0 2.163e-07 0 2.16305e-07 0.9 2.166e-07 0.9 2.16605e-07 0 2.169e-07 0 2.16905e-07 0.9 2.193e-07 0.9 2.19305e-07 0 2.226e-07 0 2.22605e-07 0.9 2.229e-07 0.9 2.22905e-07 0 2.232e-07 0 2.23205e-07 0.9 2.235e-07 0.9 2.23505e-07 0 2.238e-07 0 2.23805e-07 0.9 2.241e-07 0.9 2.24105e-07 0 2.268e-07 0 2.26805e-07 0.9 2.271e-07 0.9 2.27105e-07 0 2.274e-07 0 2.27405e-07 0.9 2.277e-07 0.9 2.27705e-07 0 2.28e-07 0 2.28005e-07 0.9 2.283e-07 0.9 2.28305e-07 0 2.304e-07 0 2.30405e-07 0.9 2.307e-07 0.9 2.30705e-07 0 2.31e-07 0 2.31005e-07 0.9 2.313e-07 0.9 2.31305e-07 0 2.316e-07 0 2.31605e-07 0.9 2.319e-07 0.9 2.31905e-07 0 2.334e-07 0 2.33405e-07 0.9 2.337e-07 0.9 2.33705e-07 0 2.34e-07 0 2.34005e-07 0.9 2.343e-07 0.9 2.34305e-07 0 2.346e-07 0 2.34605e-07 0.9 2.349e-07 0.9 2.34905e-07 0 2.358e-07 0 2.35805e-07 0.9 2.361e-07 0.9 2.36105e-07 0 2.364e-07 0 2.36405e-07 0.9 2.367e-07 0.9 2.36705e-07 0 2.37e-07 0 2.37005e-07 0.9 2.373e-07 0.9 2.37305e-07 0 2.376e-07 0 2.37605e-07 0.9 2.379e-07 0.9 2.37905e-07 0 2.382e-07 0 2.38205e-07 0.9 2.385e-07 0.9 2.38505e-07 0 2.388e-07 0 2.38805e-07 0.9 2.412e-07 0.9 2.41205e-07 0 2.445e-07 0 2.44505e-07 0.9 2.448e-07 0.9 2.44805e-07 0 2.451e-07 0 2.45105e-07 0.9 2.454e-07 0.9 2.45405e-07 0 2.457e-07 0 2.45705e-07 0.9 2.46e-07 0.9 2.46005e-07 0 2.487e-07 0 2.48705e-07 0.9 2.49e-07 0.9 2.49005e-07 0 2.493e-07 0 2.49305e-07 0.9 2.496e-07 0.9 2.49605e-07 0 2.499e-07 0 2.49905e-07 0.9 2.502e-07 0.9 2.50205e-07 0 2.523e-07 0 2.52305e-07 0.9 2.526e-07 0.9 2.52605e-07 0 2.529e-07 0 2.52905e-07 0.9 2.532e-07 0.9 2.53205e-07 0 2.535e-07 0 2.53505e-07 0.9 2.538e-07 0.9 2.53805e-07 0 2.553e-07 0 2.55305e-07 0.9 2.556e-07 0.9 2.55605e-07 0 2.559e-07 0 2.55905e-07 0.9 2.562e-07 0.9 2.56205e-07 0 2.565e-07 0 2.56505e-07 0.9 2.568e-07 0.9 2.56805e-07 0 2.577e-07 0 2.57705e-07 0.9 2.58e-07 0.9 2.58005e-07 0 2.583e-07 0 2.58305e-07 0.9 2.586e-07 0.9 2.58605e-07 0 2.589e-07 0 2.58905e-07 0.9 2.592e-07 0.9 2.59205e-07 0 2.595e-07 0 2.59505e-07 0.9 2.598e-07 0.9 2.59805e-07 0 2.601e-07 0 2.60105e-07 0.9 2.604e-07 0.9 2.60405e-07 0 2.607e-07 0 2.60705e-07 0.9 2.631e-07 0.9 2.63105e-07 0 2.664e-07 0 2.66405e-07 0.9 2.667e-07 0.9 2.66705e-07 0 2.67e-07 0 2.67005e-07 0.9 2.673e-07 0.9 2.67305e-07 0 2.676e-07 0 2.67605e-07 0.9 2.679e-07 0.9 2.67905e-07 0 2.706e-07 0 2.70605e-07 0.9 2.709e-07 0.9 2.70905e-07 0 2.712e-07 0 2.71205e-07 0.9 2.715e-07 0.9 2.71505e-07 0 2.718e-07 0 2.71805e-07 0.9 2.721e-07 0.9 2.72105e-07 0 2.742e-07 0 2.74205e-07 0.9 2.745e-07 0.9 2.74505e-07 0 2.748e-07 0 2.74805e-07 0.9 2.751e-07 0.9 2.75105e-07 0 2.754e-07 0 2.75405e-07 0.9 2.757e-07 0.9 2.75705e-07 0 2.772e-07 0 2.77205e-07 0.9 2.775e-07 0.9 2.77505e-07 0 2.778e-07 0 2.77805e-07 0.9 2.781e-07 0.9 2.78105e-07 0 2.784e-07 0 2.78405e-07 0.9 2.787e-07 0.9 2.78705e-07 0 2.796e-07 0 2.79605e-07 0.9 2.799e-07 0.9 2.79905e-07 0 2.802e-07 0 2.80205e-07 0.9 2.805e-07 0.9 2.80505e-07 0 2.808e-07 0 2.80805e-07 0.9 2.811e-07 0.9 2.81105e-07 0 2.814e-07 0 2.81405e-07 0.9 2.817e-07 0.9 2.81705e-07 0 2.82e-07 0 2.82005e-07 0.9 2.823e-07 0.9 2.82305e-07 0 2.826e-07 0 2.82605e-07 0.9 2.85e-07 0.9 2.85005e-07 0 2.883e-07 0 2.88305e-07 0.9 2.886e-07 0.9 2.88605e-07 0 2.889e-07 0 2.88905e-07 0.9 2.892e-07 0.9 2.89205e-07 0 2.895e-07 0 2.89505e-07 0.9 2.898e-07 0.9 2.89805e-07 0 2.925e-07 0 2.92505e-07 0.9 2.928e-07 0.9 2.92805e-07 0 2.931e-07 0 2.93105e-07 0.9 2.934e-07 0.9 2.93405e-07 0 2.937e-07 0 2.93705e-07 0.9 2.94e-07 0.9 2.94005e-07 0 2.961e-07 0 2.96105e-07 0.9 2.964e-07 0.9 2.96405e-07 0 2.967e-07 0 2.96705e-07 0.9 2.97e-07 0.9 2.97005e-07 0 2.973e-07 0 2.97305e-07 0.9 2.976e-07 0.9 2.97605e-07 0 2.991e-07 0 2.99105e-07 0.9 2.994e-07 0.9 2.99405e-07 0 2.997e-07 0 2.99705e-07 0.9 3e-07 0.9 3.00005e-07 0 3.003e-07 0 3.00305e-07 0.9 3.006e-07 0.9 3.00605e-07 0 3.015e-07 0 3.01505e-07 0.9 3.018e-07 0.9 3.01805e-07 0 3.021e-07 0 3.02105e-07 0.9 3.024e-07 0.9 3.02405e-07 0 3.027e-07 0 3.02705e-07 0.9 3.03e-07 0.9 3.03005e-07 0 3.033e-07 0 3.03305e-07 0.9 3.036e-07 0.9 3.03605e-07 0 3.039e-07 0 3.03905e-07 0.9 3.042e-07 0.9 3.04205e-07 0 3.045e-07 0 3.04505e-07 0.9 3.069e-07 0.9 3.06905e-07 0 3.102e-07 0 3.10205e-07 0.9 3.105e-07 0.9 3.10505e-07 0 3.108e-07 0 3.10805e-07 0.9 3.111e-07 0.9 3.11105e-07 0 3.114e-07 0 3.11405e-07 0.9 3.117e-07 0.9 3.11705e-07 0 3.144e-07 0 3.14405e-07 0.9 3.147e-07 0.9 3.14705e-07 0 3.15e-07 0 3.15005e-07 0.9 3.153e-07 0.9 3.15305e-07 0 3.156e-07 0 3.15605e-07 0.9 3.159e-07 0.9 3.15905e-07 0 3.18e-07 0 3.18005e-07 0.9 3.183e-07 0.9 3.18305e-07 0 3.186e-07 0 3.18605e-07 0.9 3.189e-07 0.9 3.18905e-07 0 3.192e-07 0 3.19205e-07 0.9 3.195e-07 0.9 3.19505e-07 0 3.21e-07 0 3.21005e-07 0.9 3.213e-07 0.9 3.21305e-07 0 3.216e-07 0 3.21605e-07 0.9 3.219e-07 0.9 3.21905e-07 0 3.222e-07 0 3.22205e-07 0.9 3.225e-07 0.9 3.22505e-07 0 3.234e-07 0 3.23405e-07 0.9 3.237e-07 0.9 3.23705e-07 0 3.24e-07 0 3.24005e-07 0.9 3.243e-07 0.9 3.24305e-07 0 3.246e-07 0 3.24605e-07 0.9 3.249e-07 0.9 3.24905e-07 0 3.252e-07 0 3.25205e-07 0.9 3.255e-07 0.9 3.25505e-07 0 3.258e-07 0 3.25805e-07 0.9 3.261e-07 0.9 3.26105e-07 0 3.264e-07 0 3.26405e-07 0.9 3.288e-07 0.9 3.28805e-07 0 3.321e-07 0 3.32105e-07 0.9 3.324e-07 0.9 3.32405e-07 0 3.327e-07 0 3.32705e-07 0.9 3.33e-07 0.9 3.33005e-07 0 3.333e-07 0 3.33305e-07 0.9 3.336e-07 0.9 3.33605e-07 0 3.363e-07 0 3.36305e-07 0.9 3.366e-07 0.9 3.36605e-07 0 3.369e-07 0 3.36905e-07 0.9 3.372e-07 0.9 3.37205e-07 0 3.375e-07 0 3.37505e-07 0.9 3.378e-07 0.9 3.37805e-07 0 3.399e-07 0 3.39905e-07 0.9 3.402e-07 0.9 3.40205e-07 0 3.405e-07 0 3.40505e-07 0.9 3.408e-07 0.9 3.40805e-07 0 3.411e-07 0 3.41105e-07 0.9 3.414e-07 0.9 3.41405e-07 0 3.429e-07 0 3.42905e-07 0.9 3.432e-07 0.9 3.43205e-07 0 3.435e-07 0 3.43505e-07 0.9 3.438e-07 0.9 3.43805e-07 0 3.441e-07 0 3.44105e-07 0.9 3.444e-07 0.9 3.44405e-07 0 3.453e-07 0 3.45305e-07 0.9 3.456e-07 0.9 3.45605e-07 0 3.459e-07 0 3.45905e-07 0.9 3.462e-07 0.9 3.46205e-07 0 3.465e-07 0 3.46505e-07 0.9 3.468e-07 0.9 3.46805e-07 0 3.471e-07 0 3.47105e-07 0.9 3.474e-07 0.9 3.47405e-07 0 3.477e-07 0 3.47705e-07 0.9 3.48e-07 0.9 3.48005e-07 0 3.483e-07 0 3.48305e-07 0.9 3.507e-07 0.9 3.50705e-07 0 3.54e-07 0 3.54005e-07 0.9 3.543e-07 0.9 3.54305e-07 0 3.546e-07 0 3.54605e-07 0.9 3.549e-07 0.9 3.54905e-07 0 3.552e-07 0 3.55205e-07 0.9 3.555e-07 0.9 3.55505e-07 0 3.582e-07 0 3.58205e-07 0.9 3.585e-07 0.9 3.58505e-07 0 3.588e-07 0 3.58805e-07 0.9 3.591e-07 0.9 3.59105e-07 0 3.594e-07 0 3.59405e-07 0.9 3.597e-07 0.9 3.59705e-07 0 3.618e-07 0 3.61805e-07 0.9 3.621e-07 0.9 3.62105e-07 0 3.624e-07 0 3.62405e-07 0.9 3.627e-07 0.9 3.62705e-07 0 3.63e-07 0 3.63005e-07 0.9 3.633e-07 0.9 3.63305e-07 0 3.648e-07 0 3.64805e-07 0.9 3.651e-07 0.9 3.65105e-07 0 3.654e-07 0 3.65405e-07 0.9 3.657e-07 0.9 3.65705e-07 0 3.66e-07 0 3.66005e-07 0.9 3.663e-07 0.9 3.66305e-07 0 3.672e-07 0 3.67205e-07 0.9 3.675e-07 0.9 3.67505e-07 0 3.678e-07 0 3.67805e-07 0.9 3.681e-07 0.9 3.68105e-07 0 3.684e-07 0 3.68405e-07 0.9 3.687e-07 0.9 3.68705e-07 0 3.69e-07 0 3.69005e-07 0.9 3.693e-07 0.9 3.69305e-07 0 3.696e-07 0 3.69605e-07 0.9 3.699e-07 0.9 3.69905e-07 0 3.702e-07 0 3.70205e-07 0.9 3.726e-07 0.9 3.72605e-07 0 3.759e-07 0 3.75905e-07 0.9 3.762e-07 0.9 3.76205e-07 0 3.765e-07 0 3.76505e-07 0.9 3.768e-07 0.9 3.76805e-07 0 3.771e-07 0 3.77105e-07 0.9 3.774e-07 0.9 3.77405e-07 0 3.801e-07 0 3.80105e-07 0.9 3.804e-07 0.9 3.80405e-07 0 3.807e-07 0 3.80705e-07 0.9 3.81e-07 0.9 3.81005e-07 0 3.813e-07 0 3.81305e-07 0.9 3.816e-07 0.9 3.81605e-07 0 3.837e-07 0 3.83705e-07 0.9 3.84e-07 0.9 3.84005e-07 0 3.843e-07 0 3.84305e-07 0.9 3.846e-07 0.9 3.84605e-07 0 3.849e-07 0 3.84905e-07 0.9 3.852e-07 0.9 3.85205e-07 0 3.867e-07 0 3.86705e-07 0.9 3.87e-07 0.9 3.87005e-07 0 3.873e-07 0 3.87305e-07 0.9 3.876e-07 0.9 3.87605e-07 0 3.879e-07 0 3.87905e-07 0.9 3.882e-07 0.9 3.88205e-07 0 3.891e-07 0 3.89105e-07 0.9 3.894e-07 0.9 3.89405e-07 0 3.897e-07 0 3.89705e-07 0.9 3.9e-07 0.9 3.90005e-07 0 3.903e-07 0 3.90305e-07 0.9 3.906e-07 0.9 3.90605e-07 0 3.909e-07 0 3.90905e-07 0.9 3.912e-07 0.9 3.91205e-07 0 3.915e-07 0 3.91505e-07 0.9 3.918e-07 0.9 3.91805e-07 0 3.921e-07 0 3.92105e-07 0.9 3.945e-07 0.9 3.94505e-07 0 3.978e-07 0 3.97805e-07 0.9 3.981e-07 0.9 3.98105e-07 0 3.984e-07 0 3.98405e-07 0.9 3.987e-07 0.9 3.98705e-07 0 3.99e-07 0 3.99005e-07 0.9 3.993e-07 0.9 3.99305e-07 0 4.02e-07 0 4.02005e-07 0.9 4.023e-07 0.9 4.02305e-07 0 4.026e-07 0 4.02605e-07 0.9 4.029e-07 0.9 4.02905e-07 0 4.032e-07 0 4.03205e-07 0.9 4.035e-07 0.9 4.03505e-07 0 4.056e-07 0 4.05605e-07 0.9 4.059e-07 0.9 4.05905e-07 0 4.062e-07 0 4.06205e-07 0.9 4.065e-07 0.9 4.06505e-07 0 4.068e-07 0 4.06805e-07 0.9 4.071e-07 0.9 4.07105e-07 0 4.086e-07 0 4.08605e-07 0.9 4.089e-07 0.9 4.08905e-07 0 4.092e-07 0 4.09205e-07 0.9 4.095e-07 0.9 4.09505e-07 0 4.098e-07 0 4.09805e-07 0.9 4.101e-07 0.9 4.10105e-07 0 4.11e-07 0 4.11005e-07 0.9 4.113e-07 0.9 4.11305e-07 0 4.116e-07 0 4.11605e-07 0.9 4.119e-07 0.9 4.11905e-07 0 4.122e-07 0 4.12205e-07 0.9 4.125e-07 0.9 4.12505e-07 0 4.128e-07 0 4.12805e-07 0.9 4.131e-07 0.9 4.13105e-07 0 4.134e-07 0 4.13405e-07 0.9 4.137e-07 0.9 4.13705e-07 0 4.14e-07 0 4.14005e-07 0.9 4.164e-07 0.9 4.16405e-07 0 4.197e-07 0 4.19705e-07 0.9 4.2e-07 0.9 4.20005e-07 0 4.203e-07 0 4.20305e-07 0.9 4.206e-07 0.9 4.20605e-07 0 4.209e-07 0 4.20905e-07 0.9 4.212e-07 0.9 4.21205e-07 0 4.239e-07 0 4.23905e-07 0.9 4.242e-07 0.9 4.24205e-07 0 4.245e-07 0 4.24505e-07 0.9 4.248e-07 0.9 4.24805e-07 0 4.251e-07 0 4.25105e-07 0.9 4.254e-07 0.9 4.25405e-07 0 4.275e-07 0 4.27505e-07 0.9 4.278e-07 0.9 4.27805e-07 0 4.281e-07 0 4.28105e-07 0.9 4.284e-07 0.9 4.28405e-07 0 4.287e-07 0 4.28705e-07 0.9 4.29e-07 0.9 4.29005e-07 0 4.305e-07 0 4.30505e-07 0.9 4.308e-07 0.9 4.30805e-07 0 4.311e-07 0 4.31105e-07 0.9 4.314e-07 0.9 4.31405e-07 0 4.317e-07 0 4.31705e-07 0.9 4.32e-07 0.9 4.32005e-07 0 4.329e-07 0 4.32905e-07 0.9 4.332e-07 0.9 4.33205e-07 0 4.335e-07 0 4.33505e-07 0.9 4.338e-07 0.9 4.33805e-07 0 4.341e-07 0 4.34105e-07 0.9 4.344e-07 0.9 4.34405e-07 0 4.347e-07 0 4.34705e-07 0.9 4.35e-07 0.9 4.35005e-07 0 4.353e-07 0 4.35305e-07 0.9 4.356e-07 0.9 4.35605e-07 0 4.359e-07 0 4.35905e-07 0.9 4.383e-07 0.9 4.38305e-07 0 4.416e-07 0 4.41605e-07 0.9 4.419e-07 0.9 4.41905e-07 0 4.422e-07 0 4.42205e-07 0.9 4.425e-07 0.9 4.42505e-07 0 4.428e-07 0 4.42805e-07 0.9 4.431e-07 0.9 4.43105e-07 0 4.458e-07 0 4.45805e-07 0.9 4.461e-07 0.9 4.46105e-07 0 4.464e-07 0 4.46405e-07 0.9 4.467e-07 0.9 4.46705e-07 0 4.47e-07 0 4.47005e-07 0.9 4.473e-07 0.9 4.47305e-07 0 4.494e-07 0 4.49405e-07 0.9 4.497e-07 0.9 4.49705e-07 0 4.5e-07 0 4.50005e-07 0.9 4.503e-07 0.9 4.50305e-07 0 4.506e-07 0 4.50605e-07 0.9 4.509e-07 0.9 4.50905e-07 0 4.524e-07 0 4.52405e-07 0.9 4.527e-07 0.9 4.52705e-07 0 4.53e-07 0 4.53005e-07 0.9 4.533e-07 0.9 4.53305e-07 0 4.536e-07 0 4.53605e-07 0.9 4.539e-07 0.9 4.53905e-07 0 4.548e-07 0 4.54805e-07 0.9 4.551e-07 0.9 4.55105e-07 0 4.554e-07 0 4.55405e-07 0.9 4.557e-07 0.9 4.55705e-07 0 4.56e-07 0 4.56005e-07 0.9 4.563e-07 0.9 4.56305e-07 0 4.566e-07 0 4.56605e-07 0.9 4.569e-07 0.9 4.56905e-07 0 4.572e-07 0 4.57205e-07 0.9 4.575e-07 0.9 4.57505e-07 0 4.578e-07 0 4.57805e-07 0.9 4.602e-07 0.9 4.60205e-07 0 4.635e-07 0 4.63505e-07 0.9 4.638e-07 0.9 4.63805e-07 0 4.641e-07 0 4.64105e-07 0.9 4.644e-07 0.9 4.64405e-07 0 4.647e-07 0 4.64705e-07 0.9 4.65e-07 0.9 4.65005e-07 0 4.677e-07 0 4.67705e-07 0.9 4.68e-07 0.9 4.68005e-07 0 4.683e-07 0 4.68305e-07 0.9 4.686e-07 0.9 4.68605e-07 0 4.689e-07 0 4.68905e-07 0.9 4.692e-07 0.9 4.69205e-07 0 4.713e-07 0 4.71305e-07 0.9 4.716e-07 0.9 4.71605e-07 0 4.719e-07 0 4.71905e-07 0.9 4.722e-07 0.9 4.72205e-07 0 4.725e-07 0 4.72505e-07 0.9 4.728e-07 0.9 4.72805e-07 0 4.743e-07 0 4.74305e-07 0.9 4.746e-07 0.9 4.74605e-07 0 4.749e-07 0 4.74905e-07 0.9 4.752e-07 0.9 4.75205e-07 0 4.755e-07 0 4.75505e-07 0.9 4.758e-07 0.9 4.75805e-07 0 4.767e-07 0 4.76705e-07 0.9 4.77e-07 0.9 4.77005e-07 0 4.773e-07 0 4.77305e-07 0.9 4.776e-07 0.9 4.77605e-07 0 4.779e-07 0 4.77905e-07 0.9 4.782e-07 0.9 4.78205e-07 0 4.785e-07 0 4.78505e-07 0.9 4.788e-07 0.9 4.78805e-07 0 4.791e-07 0 4.79105e-07 0.9 4.794e-07 0.9 4.79405e-07 0 4.797e-07 0 4.79705e-07 0.9 4.821e-07 0.9 4.82105e-07 0 4.854e-07 0 4.85405e-07 0.9 4.857e-07 0.9 4.85705e-07 0 4.86e-07 0 4.86005e-07 0.9 4.863e-07 0.9 4.86305e-07 0 4.866e-07 0 4.86605e-07 0.9 4.869e-07 0.9 4.86905e-07 0 4.896e-07 0 4.89605e-07 0.9 4.899e-07 0.9 4.89905e-07 0 4.902e-07 0 4.90205e-07 0.9 4.905e-07 0.9 4.90505e-07 0 4.908e-07 0 4.90805e-07 0.9 4.911e-07 0.9 4.91105e-07 0 4.932e-07 0 4.93205e-07 0.9 4.935e-07 0.9 4.93505e-07 0 4.938e-07 0 4.93805e-07 0.9 4.941e-07 0.9 4.94105e-07 0 4.944e-07 0 4.94405e-07 0.9 4.947e-07 0.9 4.94705e-07 0 4.962e-07 0 4.96205e-07 0.9 4.965e-07 0.9 4.96505e-07 0 4.968e-07 0 4.96805e-07 0.9 4.971e-07 0.9 4.97105e-07 0 4.974e-07 0 4.97405e-07 0.9 4.977e-07 0.9 4.97705e-07 0 4.986e-07 0 4.98605e-07 0.9 4.989e-07 0.9 4.98905e-07 0 4.992e-07 0 4.99205e-07 0.9 4.995e-07 0.9 4.99505e-07 0 4.998e-07 0 4.99805e-07 0.9 5.001e-07 0.9 5.00105e-07 0 5.004e-07 0 5.00405e-07 0.9 5.007e-07 0.9 5.00705e-07 0 5.01e-07 0 5.01005e-07 0.9 5.013e-07 0.9 5.01305e-07 0 5.016e-07 0 5.01605e-07 0.9 5.04e-07 0.9 5.04005e-07 0 5.073e-07 0 5.07305e-07 0.9 5.076e-07 0.9 5.07605e-07 0 5.079e-07 0 5.07905e-07 0.9 5.082e-07 0.9 5.08205e-07 0 5.085e-07 0 5.08505e-07 0.9 5.088e-07 0.9 5.08805e-07 0 5.115e-07 0 5.11505e-07 0.9 5.118e-07 0.9 5.11805e-07 0 5.121e-07 0 5.12105e-07 0.9 5.124e-07 0.9 5.12405e-07 0 5.127e-07 0 5.12705e-07 0.9 5.13e-07 0.9 5.13005e-07 0 5.151e-07 0 5.15105e-07 0.9 5.154e-07 0.9 5.15405e-07 0 5.157e-07 0 5.15705e-07 0.9 5.16e-07 0.9 5.16005e-07 0 5.163e-07 0 5.16305e-07 0.9 5.166e-07 0.9 5.16605e-07 0 5.181e-07 0 5.18105e-07 0.9 5.184e-07 0.9 5.18405e-07 0 5.187e-07 0 5.18705e-07 0.9 5.19e-07 0.9 5.19005e-07 0 5.193e-07 0 5.19305e-07 0.9 5.196e-07 0.9 5.19605e-07 0 5.205e-07 0 5.20505e-07 0.9 5.208e-07 0.9 5.20805e-07 0 5.211e-07 0 5.21105e-07 0.9 5.214e-07 0.9 5.21405e-07 0 5.217e-07 0 5.21705e-07 0.9 5.22e-07 0.9 5.22005e-07 0 5.223e-07 0 5.22305e-07 0.9 5.226e-07 0.9 5.22605e-07 0 5.229e-07 0 5.22905e-07 0.9 5.232e-07 0.9 5.23205e-07 0 5.235e-07 0 5.23505e-07 0.9 5.259e-07 0.9 5.25905e-07 0 5.292e-07 0 5.29205e-07 0.9 5.295e-07 0.9 5.29505e-07 0 5.298e-07 0 5.29805e-07 0.9 5.301e-07 0.9 5.30105e-07 0 5.304e-07 0 5.30405e-07 0.9 5.307e-07 0.9 5.30705e-07 0 5.334e-07 0 5.33405e-07 0.9 5.337e-07 0.9 5.33705e-07 0 5.34e-07 0 5.34005e-07 0.9 5.343e-07 0.9 5.34305e-07 0 5.346e-07 0 5.34605e-07 0.9 5.349e-07 0.9 5.34905e-07 0 5.37e-07 0 5.37005e-07 0.9 5.373e-07 0.9 5.37305e-07 0 5.376e-07 0 5.37605e-07 0.9 5.379e-07 0.9 5.37905e-07 0 5.382e-07 0 5.38205e-07 0.9 5.385e-07 0.9 5.38505e-07 0 5.4e-07 0 5.40005e-07 0.9 5.403e-07 0.9 5.40305e-07 0 5.406e-07 0 5.40605e-07 0.9 5.409e-07 0.9 5.40905e-07 0 5.412e-07 0 5.41205e-07 0.9 5.415e-07 0.9 5.41505e-07 0 5.424e-07 0 5.42405e-07 0.9 5.427e-07 0.9 5.42705e-07 0 5.43e-07 0 5.43005e-07 0.9 5.433e-07 0.9 5.43305e-07 0 5.436e-07 0 5.43605e-07 0.9 5.439e-07 0.9 5.43905e-07 0 5.442e-07 0 5.44205e-07 0.9 5.445e-07 0.9 5.44505e-07 0 5.448e-07 0 5.44805e-07 0.9 5.451e-07 0.9 5.45105e-07 0 5.454e-07 0 5.45405e-07 0.9 5.478e-07 0.9 5.47805e-07 0 5.511e-07 0 5.51105e-07 0.9 5.514e-07 0.9 5.51405e-07 0 5.517e-07 0 5.51705e-07 0.9 5.52e-07 0.9 5.52005e-07 0 5.523e-07 0 5.52305e-07 0.9 5.526e-07 0.9 5.52605e-07 0 5.553e-07 0 5.55305e-07 0.9 5.556e-07 0.9 5.55605e-07 0 5.559e-07 0 5.55905e-07 0.9 5.562e-07 0.9 5.56205e-07 0 5.565e-07 0 5.56505e-07 0.9 5.568e-07 0.9 5.56805e-07 0 5.589e-07 0 5.58905e-07 0.9 5.592e-07 0.9 5.59205e-07 0 5.595e-07 0 5.59505e-07 0.9 5.598e-07 0.9 5.59805e-07 0 5.601e-07 0 5.60105e-07 0.9 5.604e-07 0.9 5.60405e-07 0 5.619e-07 0 5.61905e-07 0.9 5.622e-07 0.9 5.62205e-07 0 5.625e-07 0 5.62505e-07 0.9 5.628e-07 0.9 5.62805e-07 0 5.631e-07 0 5.63105e-07 0.9 5.634e-07 0.9 5.63405e-07 0 5.643e-07 0 5.64305e-07 0.9 5.646e-07 0.9 5.64605e-07 0 5.649e-07 0 5.64905e-07 0.9 5.652e-07 0.9 5.65205e-07 0 5.655e-07 0 5.65505e-07 0.9 5.658e-07 0.9 5.65805e-07 0 5.661e-07 0 5.66105e-07 0.9 5.664e-07 0.9 5.66405e-07 0 5.667e-07 0 5.66705e-07 0.9 5.67e-07 0.9 5.67005e-07 0 5.673e-07 0 5.67305e-07 0.9 5.697e-07 0.9 5.69705e-07 0 5.73e-07 0 5.73005e-07 0.9 5.733e-07 0.9 5.73305e-07 0 5.736e-07 0 5.73605e-07 0.9 5.739e-07 0.9 5.73905e-07 0 5.742e-07 0 5.74205e-07 0.9 5.745e-07 0.9 5.74505e-07 0 5.772e-07 0 5.77205e-07 0.9 5.775e-07 0.9 5.77505e-07 0 5.778e-07 0 5.77805e-07 0.9 5.781e-07 0.9 5.78105e-07 0 5.784e-07 0 5.78405e-07 0.9 5.787e-07 0.9 5.78705e-07 0 5.808e-07 0 5.80805e-07 0.9 5.811e-07 0.9 5.81105e-07 0 5.814e-07 0 5.81405e-07 0.9 5.817e-07 0.9 5.81705e-07 0 5.82e-07 0 5.82005e-07 0.9 5.823e-07 0.9 5.82305e-07 0 5.838e-07 0 5.83805e-07 0.9 5.841e-07 0.9 5.84105e-07 0 5.844e-07 0 5.84405e-07 0.9 5.847e-07 0.9 5.84705e-07 0 5.85e-07 0 5.85005e-07 0.9 5.853e-07 0.9 5.85305e-07 0 5.862e-07 0 5.86205e-07 0.9 5.865e-07 0.9 5.86505e-07 0 5.868e-07 0 5.86805e-07 0.9 5.871e-07 0.9 5.87105e-07 0 5.874e-07 0 5.87405e-07 0.9 5.877e-07 0.9 5.87705e-07 0 5.88e-07 0 5.88005e-07 0.9 5.883e-07 0.9 5.88305e-07 0 5.886e-07 0 5.88605e-07 0.9 5.889e-07 0.9 5.88905e-07 0 5.892e-07 0 5.89205e-07 0.9]
MDN0 (i0 src0 0 0) nmos_rvt l=20n nfin=1
MDP0 (i0 src0 vdd vdd) pmos_rvt l=20n nfin=2
VS1 (src1 0) vsource type=pwl wave=[0 0.9 3e-10 0.9 3.05e-10 0 1.8e-09 0 1.805e-09 0.9 2.1e-09 0.9 2.105e-09 0 2.4e-09 0 2.405e-09 0.9 2.7e-09 0.9 2.705e-09 0 3e-09 0 3.005e-09 0.9 3.3e-09 0.9 3.305e-09 0 3.6e-09 0 3.605e-09 0.9 3.9e-09 0.9 3.905e-09 0 4.2e-09 0 4.205e-09 0.9 4.5e-09 0.9 4.505e-09 0 4.8e-09 0 4.805e-09 0.9 5.1e-09 0.9 5.105e-09 0 6e-09 0 6.005e-09 0.9 6.3e-09 0.9 6.305e-09 0 6.6e-09 0 6.605e-09 0.9 6.9e-09 0.9 6.905e-09 0 7.2e-09 0 7.205e-09 0.9 7.5e-09 0.9 7.505e-09 0 7.8e-09 0 7.805e-09 0.9 8.1e-09 0.9 8.105e-09 0 8.4e-09 0 8.405e-09 0.9 8.7e-09 0.9 8.705e-09 0 9e-09 0 9.005e-09 0.9 9.3e-09 0.9 9.305e-09 0 9.6e-09 0 9.605e-09 0.9 9.9e-09 0.9 9.905e-09 0 1.02e-08 0 1.0205e-08 0.9 1.05e-08 0.9 1.0505e-08 0 1.08e-08 0 1.0805e-08 0.9 1.11e-08 0.9 1.1105e-08 0 1.14e-08 0 1.1405e-08 0.9 1.17e-08 0.9 1.1705e-08 0 1.2e-08 0 1.2005e-08 0.9 1.23e-08 0.9 1.2305e-08 0 1.26e-08 0 1.2605e-08 0.9 2.22e-08 0.9 2.2205e-08 0 2.37e-08 0 2.3705e-08 0.9 2.4e-08 0.9 2.4005e-08 0 2.43e-08 0 2.4305e-08 0.9 2.46e-08 0.9 2.4605e-08 0 2.49e-08 0 2.4905e-08 0.9 2.52e-08 0.9 2.5205e-08 0 2.55e-08 0 2.5505e-08 0.9 2.58e-08 0.9 2.5805e-08 0 2.61e-08 0 2.6105e-08 0.9 2.64e-08 0.9 2.6405e-08 0 2.67e-08 0 2.6705e-08 0.9 2.7e-08 0.9 2.7005e-08 0 2.79e-08 0 2.7905e-08 0.9 2.82e-08 0.9 2.8205e-08 0 2.85e-08 0 2.8505e-08 0.9 2.88e-08 0.9 2.8805e-08 0 2.91e-08 0 2.9105e-08 0.9 2.94e-08 0.9 2.9405e-08 0 2.97e-08 0 2.9705e-08 0.9 3e-08 0.9 3.0005e-08 0 3.03e-08 0 3.0305e-08 0.9 3.06e-08 0.9 3.0605e-08 0 3.09e-08 0 3.0905e-08 0.9 3.12e-08 0.9 3.1205e-08 0 3.15e-08 0 3.1505e-08 0.9 3.18e-08 0.9 3.1805e-08 0 3.21e-08 0 3.2105e-08 0.9 3.24e-08 0.9 3.2405e-08 0 3.27e-08 0 3.2705e-08 0.9 3.3e-08 0.9 3.3005e-08 0 3.33e-08 0 3.3305e-08 0.9 3.36e-08 0.9 3.3605e-08 0 3.39e-08 0 3.3905e-08 0.9 3.42e-08 0.9 3.4205e-08 0 3.45e-08 0 3.4505e-08 0.9 4.41e-08 0.9 4.4105e-08 0 4.56e-08 0 4.5605e-08 0.9 4.59e-08 0.9 4.5905e-08 0 4.62e-08 0 4.6205e-08 0.9 4.65e-08 0.9 4.6505e-08 0 4.68e-08 0 4.6805e-08 0.9 4.71e-08 0.9 4.7105e-08 0 4.74e-08 0 4.7405e-08 0.9 4.77e-08 0.9 4.7705e-08 0 4.8e-08 0 4.8005e-08 0.9 4.83e-08 0.9 4.8305e-08 0 4.86e-08 0 4.8605e-08 0.9 4.89e-08 0.9 4.8905e-08 0 4.98e-08 0 4.9805e-08 0.9 5.01e-08 0.9 5.0105e-08 0 5.04e-08 0 5.0405e-08 0.9 5.07e-08 0.9 5.0705e-08 0 5.1e-08 0 5.1005e-08 0.9 5.13e-08 0.9 5.1305e-08 0 5.16e-08 0 5.1605e-08 0.9 5.19e-08 0.9 5.1905e-08 0 5.22e-08 0 5.2205e-08 0.9 5.25e-08 0.9 5.2505e-08 0 5.28e-08 0 5.2805e-08 0.9 5.31e-08 0.9 5.3105e-08 0 5.34e-08 0 5.3405e-08 0.9 5.37e-08 0.9 5.3705e-08 0 5.4e-08 0 5.4005e-08 0.9 5.43e-08 0.9 5.4305e-08 0 5.46e-08 0 5.4605e-08 0.9 5.49e-08 0.9 5.4905e-08 0 5.52e-08 0 5.5205e-08 0.9 5.55e-08 0.9 5.5505e-08 0 5.58e-08 0 5.5805e-08 0.9 5.61e-08 0.9 5.6105e-08 0 5.64e-08 0 5.6405e-08 0.9 6.6e-08 0.9 6.6005e-08 0 6.75e-08 0 6.7505e-08 0.9 6.78e-08 0.9 6.7805e-08 0 6.81e-08 0 6.8105e-08 0.9 6.84e-08 0.9 6.8405e-08 0 6.87e-08 0 6.8705e-08 0.9 6.9e-08 0.9 6.9005e-08 0 6.93e-08 0 6.9305e-08 0.9 6.96e-08 0.9 6.9605e-08 0 6.99e-08 0 6.9905e-08 0.9 7.02e-08 0.9 7.0205e-08 0 7.05e-08 0 7.0505e-08 0.9 7.08e-08 0.9 7.0805e-08 0 7.17e-08 0 7.1705e-08 0.9 7.2e-08 0.9 7.2005e-08 0 7.23e-08 0 7.2305e-08 0.9 7.26e-08 0.9 7.2605e-08 0 7.29e-08 0 7.2905e-08 0.9 7.32e-08 0.9 7.3205e-08 0 7.35e-08 0 7.3505e-08 0.9 7.38e-08 0.9 7.3805e-08 0 7.41e-08 0 7.4105e-08 0.9 7.44e-08 0.9 7.4405e-08 0 7.47e-08 0 7.4705e-08 0.9 7.5e-08 0.9 7.5005e-08 0 7.53e-08 0 7.5305e-08 0.9 7.56e-08 0.9 7.5605e-08 0 7.59e-08 0 7.5905e-08 0.9 7.62e-08 0.9 7.6205e-08 0 7.65e-08 0 7.6505e-08 0.9 7.68e-08 0.9 7.6805e-08 0 7.71e-08 0 7.7105e-08 0.9 7.74e-08 0.9 7.7405e-08 0 7.77e-08 0 7.7705e-08 0.9 7.8e-08 0.9 7.8005e-08 0 7.83e-08 0 7.8305e-08 0.9 8.79e-08 0.9 8.7905e-08 0 8.94e-08 0 8.9405e-08 0.9 8.97e-08 0.9 8.9705e-08 0 9e-08 0 9.0005e-08 0.9 9.03e-08 0.9 9.0305e-08 0 9.06e-08 0 9.0605e-08 0.9 9.09e-08 0.9 9.0905e-08 0 9.12e-08 0 9.1205e-08 0.9 9.15e-08 0.9 9.1505e-08 0 9.18e-08 0 9.1805e-08 0.9 9.21e-08 0.9 9.2105e-08 0 9.24e-08 0 9.2405e-08 0.9 9.27e-08 0.9 9.2705e-08 0 9.36e-08 0 9.3605e-08 0.9 9.39e-08 0.9 9.3905e-08 0 9.42e-08 0 9.4205e-08 0.9 9.45e-08 0.9 9.4505e-08 0 9.48e-08 0 9.4805e-08 0.9 9.51e-08 0.9 9.5105e-08 0 9.54e-08 0 9.5405e-08 0.9 9.57e-08 0.9 9.5705e-08 0 9.6e-08 0 9.6005e-08 0.9 9.63e-08 0.9 9.6305e-08 0 9.66e-08 0 9.6605e-08 0.9 9.69e-08 0.9 9.6905e-08 0 9.72e-08 0 9.7205e-08 0.9 9.75e-08 0.9 9.7505e-08 0 9.78e-08 0 9.7805e-08 0.9 9.81e-08 0.9 9.8105e-08 0 9.84e-08 0 9.8405e-08 0.9 9.87e-08 0.9 9.8705e-08 0 9.9e-08 0 9.9005e-08 0.9 9.93e-08 0.9 9.9305e-08 0 9.96e-08 0 9.9605e-08 0.9 9.99e-08 0.9 9.9905e-08 0 1.002e-07 0 1.00205e-07 0.9 1.098e-07 0.9 1.09805e-07 0 1.113e-07 0 1.11305e-07 0.9 1.116e-07 0.9 1.11605e-07 0 1.119e-07 0 1.11905e-07 0.9 1.122e-07 0.9 1.12205e-07 0 1.125e-07 0 1.12505e-07 0.9 1.128e-07 0.9 1.12805e-07 0 1.131e-07 0 1.13105e-07 0.9 1.134e-07 0.9 1.13405e-07 0 1.137e-07 0 1.13705e-07 0.9 1.14e-07 0.9 1.14005e-07 0 1.143e-07 0 1.14305e-07 0.9 1.146e-07 0.9 1.14605e-07 0 1.155e-07 0 1.15505e-07 0.9 1.158e-07 0.9 1.15805e-07 0 1.161e-07 0 1.16105e-07 0.9 1.164e-07 0.9 1.16405e-07 0 1.167e-07 0 1.16705e-07 0.9 1.17e-07 0.9 1.17005e-07 0 1.173e-07 0 1.17305e-07 0.9 1.176e-07 0.9 1.17605e-07 0 1.179e-07 0 1.17905e-07 0.9 1.182e-07 0.9 1.18205e-07 0 1.185e-07 0 1.18505e-07 0.9 1.188e-07 0.9 1.18805e-07 0 1.191e-07 0 1.19105e-07 0.9 1.194e-07 0.9 1.19405e-07 0 1.197e-07 0 1.19705e-07 0.9 1.2e-07 0.9 1.20005e-07 0 1.203e-07 0 1.20305e-07 0.9 1.206e-07 0.9 1.20605e-07 0 1.209e-07 0 1.20905e-07 0.9 1.212e-07 0.9 1.21205e-07 0 1.215e-07 0 1.21505e-07 0.9 1.218e-07 0.9 1.21805e-07 0 1.221e-07 0 1.22105e-07 0.9 1.317e-07 0.9 1.31705e-07 0 1.332e-07 0 1.33205e-07 0.9 1.335e-07 0.9 1.33505e-07 0 1.338e-07 0 1.33805e-07 0.9 1.341e-07 0.9 1.34105e-07 0 1.344e-07 0 1.34405e-07 0.9 1.347e-07 0.9 1.34705e-07 0 1.35e-07 0 1.35005e-07 0.9 1.353e-07 0.9 1.35305e-07 0 1.356e-07 0 1.35605e-07 0.9 1.359e-07 0.9 1.35905e-07 0 1.362e-07 0 1.36205e-07 0.9 1.365e-07 0.9 1.36505e-07 0 1.374e-07 0 1.37405e-07 0.9 1.377e-07 0.9 1.37705e-07 0 1.38e-07 0 1.38005e-07 0.9 1.383e-07 0.9 1.38305e-07 0 1.386e-07 0 1.38605e-07 0.9 1.389e-07 0.9 1.38905e-07 0 1.392e-07 0 1.39205e-07 0.9 1.395e-07 0.9 1.39505e-07 0 1.398e-07 0 1.39805e-07 0.9 1.401e-07 0.9 1.40105e-07 0 1.404e-07 0 1.40405e-07 0.9 1.407e-07 0.9 1.40705e-07 0 1.41e-07 0 1.41005e-07 0.9 1.413e-07 0.9 1.41305e-07 0 1.416e-07 0 1.41605e-07 0.9 1.419e-07 0.9 1.41905e-07 0 1.422e-07 0 1.42205e-07 0.9 1.425e-07 0.9 1.42505e-07 0 1.428e-07 0 1.42805e-07 0.9 1.431e-07 0.9 1.43105e-07 0 1.434e-07 0 1.43405e-07 0.9 1.437e-07 0.9 1.43705e-07 0 1.44e-07 0 1.44005e-07 0.9 1.536e-07 0.9 1.53605e-07 0 1.551e-07 0 1.55105e-07 0.9 1.554e-07 0.9 1.55405e-07 0 1.557e-07 0 1.55705e-07 0.9 1.56e-07 0.9 1.56005e-07 0 1.563e-07 0 1.56305e-07 0.9 1.566e-07 0.9 1.56605e-07 0 1.569e-07 0 1.56905e-07 0.9 1.572e-07 0.9 1.57205e-07 0 1.575e-07 0 1.57505e-07 0.9 1.578e-07 0.9 1.57805e-07 0 1.581e-07 0 1.58105e-07 0.9 1.584e-07 0.9 1.58405e-07 0 1.593e-07 0 1.59305e-07 0.9 1.596e-07 0.9 1.59605e-07 0 1.599e-07 0 1.59905e-07 0.9 1.602e-07 0.9 1.60205e-07 0 1.605e-07 0 1.60505e-07 0.9 1.608e-07 0.9 1.60805e-07 0 1.611e-07 0 1.61105e-07 0.9 1.614e-07 0.9 1.61405e-07 0 1.617e-07 0 1.61705e-07 0.9 1.62e-07 0.9 1.62005e-07 0 1.623e-07 0 1.62305e-07 0.9 1.626e-07 0.9 1.62605e-07 0 1.629e-07 0 1.62905e-07 0.9 1.632e-07 0.9 1.63205e-07 0 1.635e-07 0 1.63505e-07 0.9 1.638e-07 0.9 1.63805e-07 0 1.641e-07 0 1.64105e-07 0.9 1.644e-07 0.9 1.64405e-07 0 1.647e-07 0 1.64705e-07 0.9 1.65e-07 0.9 1.65005e-07 0 1.653e-07 0 1.65305e-07 0.9 1.656e-07 0.9 1.65605e-07 0 1.659e-07 0 1.65905e-07 0.9 1.755e-07 0.9 1.75505e-07 0 1.77e-07 0 1.77005e-07 0.9 1.773e-07 0.9 1.77305e-07 0 1.776e-07 0 1.77605e-07 0.9 1.779e-07 0.9 1.77905e-07 0 1.782e-07 0 1.78205e-07 0.9 1.785e-07 0.9 1.78505e-07 0 1.788e-07 0 1.78805e-07 0.9 1.791e-07 0.9 1.79105e-07 0 1.794e-07 0 1.79405e-07 0.9 1.797e-07 0.9 1.79705e-07 0 1.8e-07 0 1.80005e-07 0.9 1.803e-07 0.9 1.80305e-07 0 1.812e-07 0 1.81205e-07 0.9 1.815e-07 0.9 1.81505e-07 0 1.818e-07 0 1.81805e-07 0.9 1.821e-07 0.9 1.82105e-07 0 1.824e-07 0 1.82405e-07 0.9 1.827e-07 0.9 1.82705e-07 0 1.83e-07 0 1.83005e-07 0.9 1.833e-07 0.9 1.83305e-07 0 1.836e-07 0 1.83605e-07 0.9 1.839e-07 0.9 1.83905e-07 0 1.842e-07 0 1.84205e-07 0.9 1.845e-07 0.9 1.84505e-07 0 1.848e-07 0 1.84805e-07 0.9 1.851e-07 0.9 1.85105e-07 0 1.854e-07 0 1.85405e-07 0.9 1.857e-07 0.9 1.85705e-07 0 1.86e-07 0 1.86005e-07 0.9 1.863e-07 0.9 1.86305e-07 0 1.866e-07 0 1.86605e-07 0.9 1.869e-07 0.9 1.86905e-07 0 1.872e-07 0 1.87205e-07 0.9 1.875e-07 0.9 1.87505e-07 0 1.878e-07 0 1.87805e-07 0.9 1.974e-07 0.9 1.97405e-07 0 1.989e-07 0 1.98905e-07 0.9 1.992e-07 0.9 1.99205e-07 0 1.995e-07 0 1.99505e-07 0.9 1.998e-07 0.9 1.99805e-07 0 2.001e-07 0 2.00105e-07 0.9 2.004e-07 0.9 2.00405e-07 0 2.007e-07 0 2.00705e-07 0.9 2.01e-07 0.9 2.01005e-07 0 2.013e-07 0 2.01305e-07 0.9 2.016e-07 0.9 2.01605e-07 0 2.019e-07 0 2.01905e-07 0.9 2.022e-07 0.9 2.02205e-07 0 2.031e-07 0 2.03105e-07 0.9 2.034e-07 0.9 2.03405e-07 0 2.037e-07 0 2.03705e-07 0.9 2.04e-07 0.9 2.04005e-07 0 2.043e-07 0 2.04305e-07 0.9 2.046e-07 0.9 2.04605e-07 0 2.049e-07 0 2.04905e-07 0.9 2.052e-07 0.9 2.05205e-07 0 2.055e-07 0 2.05505e-07 0.9 2.058e-07 0.9 2.05805e-07 0 2.061e-07 0 2.06105e-07 0.9 2.064e-07 0.9 2.06405e-07 0 2.067e-07 0 2.06705e-07 0.9 2.07e-07 0.9 2.07005e-07 0 2.073e-07 0 2.07305e-07 0.9 2.076e-07 0.9 2.07605e-07 0 2.079e-07 0 2.07905e-07 0.9 2.082e-07 0.9 2.08205e-07 0 2.085e-07 0 2.08505e-07 0.9 2.088e-07 0.9 2.08805e-07 0 2.091e-07 0 2.09105e-07 0.9 2.094e-07 0.9 2.09405e-07 0 2.097e-07 0 2.09705e-07 0.9 2.193e-07 0.9 2.19305e-07 0 2.208e-07 0 2.20805e-07 0.9 2.211e-07 0.9 2.21105e-07 0 2.214e-07 0 2.21405e-07 0.9 2.217e-07 0.9 2.21705e-07 0 2.22e-07 0 2.22005e-07 0.9 2.223e-07 0.9 2.22305e-07 0 2.226e-07 0 2.22605e-07 0.9 2.229e-07 0.9 2.22905e-07 0 2.232e-07 0 2.23205e-07 0.9 2.235e-07 0.9 2.23505e-07 0 2.238e-07 0 2.23805e-07 0.9 2.241e-07 0.9 2.24105e-07 0 2.25e-07 0 2.25005e-07 0.9 2.253e-07 0.9 2.25305e-07 0 2.256e-07 0 2.25605e-07 0.9 2.259e-07 0.9 2.25905e-07 0 2.262e-07 0 2.26205e-07 0.9 2.265e-07 0.9 2.26505e-07 0 2.268e-07 0 2.26805e-07 0.9 2.271e-07 0.9 2.27105e-07 0 2.274e-07 0 2.27405e-07 0.9 2.277e-07 0.9 2.27705e-07 0 2.28e-07 0 2.28005e-07 0.9 2.283e-07 0.9 2.28305e-07 0 2.286e-07 0 2.28605e-07 0.9 2.289e-07 0.9 2.28905e-07 0 2.292e-07 0 2.29205e-07 0.9 2.295e-07 0.9 2.29505e-07 0 2.298e-07 0 2.29805e-07 0.9 2.301e-07 0.9 2.30105e-07 0 2.304e-07 0 2.30405e-07 0.9 2.307e-07 0.9 2.30705e-07 0 2.31e-07 0 2.31005e-07 0.9 2.313e-07 0.9 2.31305e-07 0 2.316e-07 0 2.31605e-07 0.9 2.412e-07 0.9 2.41205e-07 0 2.427e-07 0 2.42705e-07 0.9 2.43e-07 0.9 2.43005e-07 0 2.433e-07 0 2.43305e-07 0.9 2.436e-07 0.9 2.43605e-07 0 2.439e-07 0 2.43905e-07 0.9 2.442e-07 0.9 2.44205e-07 0 2.445e-07 0 2.44505e-07 0.9 2.448e-07 0.9 2.44805e-07 0 2.451e-07 0 2.45105e-07 0.9 2.454e-07 0.9 2.45405e-07 0 2.457e-07 0 2.45705e-07 0.9 2.46e-07 0.9 2.46005e-07 0 2.469e-07 0 2.46905e-07 0.9 2.472e-07 0.9 2.47205e-07 0 2.475e-07 0 2.47505e-07 0.9 2.478e-07 0.9 2.47805e-07 0 2.481e-07 0 2.48105e-07 0.9 2.484e-07 0.9 2.48405e-07 0 2.487e-07 0 2.48705e-07 0.9 2.49e-07 0.9 2.49005e-07 0 2.493e-07 0 2.49305e-07 0.9 2.496e-07 0.9 2.49605e-07 0 2.499e-07 0 2.49905e-07 0.9 2.502e-07 0.9 2.50205e-07 0 2.505e-07 0 2.50505e-07 0.9 2.508e-07 0.9 2.50805e-07 0 2.511e-07 0 2.51105e-07 0.9 2.514e-07 0.9 2.51405e-07 0 2.517e-07 0 2.51705e-07 0.9 2.52e-07 0.9 2.52005e-07 0 2.523e-07 0 2.52305e-07 0.9 2.526e-07 0.9 2.52605e-07 0 2.529e-07 0 2.52905e-07 0.9 2.532e-07 0.9 2.53205e-07 0 2.535e-07 0 2.53505e-07 0.9 2.631e-07 0.9 2.63105e-07 0 2.646e-07 0 2.64605e-07 0.9 2.649e-07 0.9 2.64905e-07 0 2.652e-07 0 2.65205e-07 0.9 2.655e-07 0.9 2.65505e-07 0 2.658e-07 0 2.65805e-07 0.9 2.661e-07 0.9 2.66105e-07 0 2.664e-07 0 2.66405e-07 0.9 2.667e-07 0.9 2.66705e-07 0 2.67e-07 0 2.67005e-07 0.9 2.673e-07 0.9 2.67305e-07 0 2.676e-07 0 2.67605e-07 0.9 2.679e-07 0.9 2.67905e-07 0 2.688e-07 0 2.68805e-07 0.9 2.691e-07 0.9 2.69105e-07 0 2.694e-07 0 2.69405e-07 0.9 2.697e-07 0.9 2.69705e-07 0 2.7e-07 0 2.70005e-07 0.9 2.703e-07 0.9 2.70305e-07 0 2.706e-07 0 2.70605e-07 0.9 2.709e-07 0.9 2.70905e-07 0 2.712e-07 0 2.71205e-07 0.9 2.715e-07 0.9 2.71505e-07 0 2.718e-07 0 2.71805e-07 0.9 2.721e-07 0.9 2.72105e-07 0 2.724e-07 0 2.72405e-07 0.9 2.727e-07 0.9 2.72705e-07 0 2.73e-07 0 2.73005e-07 0.9 2.733e-07 0.9 2.73305e-07 0 2.736e-07 0 2.73605e-07 0.9 2.739e-07 0.9 2.73905e-07 0 2.742e-07 0 2.74205e-07 0.9 2.745e-07 0.9 2.74505e-07 0 2.748e-07 0 2.74805e-07 0.9 2.751e-07 0.9 2.75105e-07 0 2.754e-07 0 2.75405e-07 0.9 2.85e-07 0.9 2.85005e-07 0 2.865e-07 0 2.86505e-07 0.9 2.868e-07 0.9 2.86805e-07 0 2.871e-07 0 2.87105e-07 0.9 2.874e-07 0.9 2.87405e-07 0 2.877e-07 0 2.87705e-07 0.9 2.88e-07 0.9 2.88005e-07 0 2.883e-07 0 2.88305e-07 0.9 2.886e-07 0.9 2.88605e-07 0 2.889e-07 0 2.88905e-07 0.9 2.892e-07 0.9 2.89205e-07 0 2.895e-07 0 2.89505e-07 0.9 2.898e-07 0.9 2.89805e-07 0 2.907e-07 0 2.90705e-07 0.9 2.91e-07 0.9 2.91005e-07 0 2.913e-07 0 2.91305e-07 0.9 2.916e-07 0.9 2.91605e-07 0 2.919e-07 0 2.91905e-07 0.9 2.922e-07 0.9 2.92205e-07 0 2.925e-07 0 2.92505e-07 0.9 2.928e-07 0.9 2.92805e-07 0 2.931e-07 0 2.93105e-07 0.9 2.934e-07 0.9 2.93405e-07 0 2.937e-07 0 2.93705e-07 0.9 2.94e-07 0.9 2.94005e-07 0 2.943e-07 0 2.94305e-07 0.9 2.946e-07 0.9 2.94605e-07 0 2.949e-07 0 2.94905e-07 0.9 2.952e-07 0.9 2.95205e-07 0 2.955e-07 0 2.95505e-07 0.9 2.958e-07 0.9 2.95805e-07 0 2.961e-07 0 2.96105e-07 0.9 2.964e-07 0.9 2.96405e-07 0 2.967e-07 0 2.96705e-07 0.9 2.97e-07 0.9 2.97005e-07 0 2.973e-07 0 2.97305e-07 0.9 3.069e-07 0.9 3.06905e-07 0 3.084e-07 0 3.08405e-07 0.9 3.087e-07 0.9 3.08705e-07 0 3.09e-07 0 3.09005e-07 0.9 3.093e-07 0.9 3.09305e-07 0 3.096e-07 0 3.09605e-07 0.9 3.099e-07 0.9 3.09905e-07 0 3.102e-07 0 3.10205e-07 0.9 3.105e-07 0.9 3.10505e-07 0 3.108e-07 0 3.10805e-07 0.9 3.111e-07 0.9 3.11105e-07 0 3.114e-07 0 3.11405e-07 0.9 3.117e-07 0.9 3.11705e-07 0 3.126e-07 0 3.12605e-07 0.9 3.129e-07 0.9 3.12905e-07 0 3.132e-07 0 3.13205e-07 0.9 3.135e-07 0.9 3.13505e-07 0 3.138e-07 0 3.13805e-07 0.9 3.141e-07 0.9 3.14105e-07 0 3.144e-07 0 3.14405e-07 0.9 3.147e-07 0.9 3.14705e-07 0 3.15e-07 0 3.15005e-07 0.9 3.153e-07 0.9 3.15305e-07 0 3.156e-07 0 3.15605e-07 0.9 3.159e-07 0.9 3.15905e-07 0 3.162e-07 0 3.16205e-07 0.9 3.165e-07 0.9 3.16505e-07 0 3.168e-07 0 3.16805e-07 0.9 3.171e-07 0.9 3.17105e-07 0 3.174e-07 0 3.17405e-07 0.9 3.177e-07 0.9 3.17705e-07 0 3.18e-07 0 3.18005e-07 0.9 3.183e-07 0.9 3.18305e-07 0 3.186e-07 0 3.18605e-07 0.9 3.189e-07 0.9 3.18905e-07 0 3.192e-07 0 3.19205e-07 0.9 3.288e-07 0.9 3.28805e-07 0 3.303e-07 0 3.30305e-07 0.9 3.306e-07 0.9 3.30605e-07 0 3.309e-07 0 3.30905e-07 0.9 3.312e-07 0.9 3.31205e-07 0 3.315e-07 0 3.31505e-07 0.9 3.318e-07 0.9 3.31805e-07 0 3.321e-07 0 3.32105e-07 0.9 3.324e-07 0.9 3.32405e-07 0 3.327e-07 0 3.32705e-07 0.9 3.33e-07 0.9 3.33005e-07 0 3.333e-07 0 3.33305e-07 0.9 3.336e-07 0.9 3.33605e-07 0 3.345e-07 0 3.34505e-07 0.9 3.348e-07 0.9 3.34805e-07 0 3.351e-07 0 3.35105e-07 0.9 3.354e-07 0.9 3.35405e-07 0 3.357e-07 0 3.35705e-07 0.9 3.36e-07 0.9 3.36005e-07 0 3.363e-07 0 3.36305e-07 0.9 3.366e-07 0.9 3.36605e-07 0 3.369e-07 0 3.36905e-07 0.9 3.372e-07 0.9 3.37205e-07 0 3.375e-07 0 3.37505e-07 0.9 3.378e-07 0.9 3.37805e-07 0 3.381e-07 0 3.38105e-07 0.9 3.384e-07 0.9 3.38405e-07 0 3.387e-07 0 3.38705e-07 0.9 3.39e-07 0.9 3.39005e-07 0 3.393e-07 0 3.39305e-07 0.9 3.396e-07 0.9 3.39605e-07 0 3.399e-07 0 3.39905e-07 0.9 3.402e-07 0.9 3.40205e-07 0 3.405e-07 0 3.40505e-07 0.9 3.408e-07 0.9 3.40805e-07 0 3.411e-07 0 3.41105e-07 0.9 3.507e-07 0.9 3.50705e-07 0 3.522e-07 0 3.52205e-07 0.9 3.525e-07 0.9 3.52505e-07 0 3.528e-07 0 3.52805e-07 0.9 3.531e-07 0.9 3.53105e-07 0 3.534e-07 0 3.53405e-07 0.9 3.537e-07 0.9 3.53705e-07 0 3.54e-07 0 3.54005e-07 0.9 3.543e-07 0.9 3.54305e-07 0 3.546e-07 0 3.54605e-07 0.9 3.549e-07 0.9 3.54905e-07 0 3.552e-07 0 3.55205e-07 0.9 3.555e-07 0.9 3.55505e-07 0 3.564e-07 0 3.56405e-07 0.9 3.567e-07 0.9 3.56705e-07 0 3.57e-07 0 3.57005e-07 0.9 3.573e-07 0.9 3.57305e-07 0 3.576e-07 0 3.57605e-07 0.9 3.579e-07 0.9 3.57905e-07 0 3.582e-07 0 3.58205e-07 0.9 3.585e-07 0.9 3.58505e-07 0 3.588e-07 0 3.58805e-07 0.9 3.591e-07 0.9 3.59105e-07 0 3.594e-07 0 3.59405e-07 0.9 3.597e-07 0.9 3.59705e-07 0 3.6e-07 0 3.60005e-07 0.9 3.603e-07 0.9 3.60305e-07 0 3.606e-07 0 3.60605e-07 0.9 3.609e-07 0.9 3.60905e-07 0 3.612e-07 0 3.61205e-07 0.9 3.615e-07 0.9 3.61505e-07 0 3.618e-07 0 3.61805e-07 0.9 3.621e-07 0.9 3.62105e-07 0 3.624e-07 0 3.62405e-07 0.9 3.627e-07 0.9 3.62705e-07 0 3.63e-07 0 3.63005e-07 0.9 3.726e-07 0.9 3.72605e-07 0 3.741e-07 0 3.74105e-07 0.9 3.744e-07 0.9 3.74405e-07 0 3.747e-07 0 3.74705e-07 0.9 3.75e-07 0.9 3.75005e-07 0 3.753e-07 0 3.75305e-07 0.9 3.756e-07 0.9 3.75605e-07 0 3.759e-07 0 3.75905e-07 0.9 3.762e-07 0.9 3.76205e-07 0 3.765e-07 0 3.76505e-07 0.9 3.768e-07 0.9 3.76805e-07 0 3.771e-07 0 3.77105e-07 0.9 3.774e-07 0.9 3.77405e-07 0 3.783e-07 0 3.78305e-07 0.9 3.786e-07 0.9 3.78605e-07 0 3.789e-07 0 3.78905e-07 0.9 3.792e-07 0.9 3.79205e-07 0 3.795e-07 0 3.79505e-07 0.9 3.798e-07 0.9 3.79805e-07 0 3.801e-07 0 3.80105e-07 0.9 3.804e-07 0.9 3.80405e-07 0 3.807e-07 0 3.80705e-07 0.9 3.81e-07 0.9 3.81005e-07 0 3.813e-07 0 3.81305e-07 0.9 3.816e-07 0.9 3.81605e-07 0 3.819e-07 0 3.81905e-07 0.9 3.822e-07 0.9 3.82205e-07 0 3.825e-07 0 3.82505e-07 0.9 3.828e-07 0.9 3.82805e-07 0 3.831e-07 0 3.83105e-07 0.9 3.834e-07 0.9 3.83405e-07 0 3.837e-07 0 3.83705e-07 0.9 3.84e-07 0.9 3.84005e-07 0 3.843e-07 0 3.84305e-07 0.9 3.846e-07 0.9 3.84605e-07 0 3.849e-07 0 3.84905e-07 0.9 3.945e-07 0.9 3.94505e-07 0 3.96e-07 0 3.96005e-07 0.9 3.963e-07 0.9 3.96305e-07 0 3.966e-07 0 3.96605e-07 0.9 3.969e-07 0.9 3.96905e-07 0 3.972e-07 0 3.97205e-07 0.9 3.975e-07 0.9 3.97505e-07 0 3.978e-07 0 3.97805e-07 0.9 3.981e-07 0.9 3.98105e-07 0 3.984e-07 0 3.98405e-07 0.9 3.987e-07 0.9 3.98705e-07 0 3.99e-07 0 3.99005e-07 0.9 3.993e-07 0.9 3.99305e-07 0 4.002e-07 0 4.00205e-07 0.9 4.005e-07 0.9 4.00505e-07 0 4.008e-07 0 4.00805e-07 0.9 4.011e-07 0.9 4.01105e-07 0 4.014e-07 0 4.01405e-07 0.9 4.017e-07 0.9 4.01705e-07 0 4.02e-07 0 4.02005e-07 0.9 4.023e-07 0.9 4.02305e-07 0 4.026e-07 0 4.02605e-07 0.9 4.029e-07 0.9 4.02905e-07 0 4.032e-07 0 4.03205e-07 0.9 4.035e-07 0.9 4.03505e-07 0 4.038e-07 0 4.03805e-07 0.9 4.041e-07 0.9 4.04105e-07 0 4.044e-07 0 4.04405e-07 0.9 4.047e-07 0.9 4.04705e-07 0 4.05e-07 0 4.05005e-07 0.9 4.053e-07 0.9 4.05305e-07 0 4.056e-07 0 4.05605e-07 0.9 4.059e-07 0.9 4.05905e-07 0 4.062e-07 0 4.06205e-07 0.9 4.065e-07 0.9 4.06505e-07 0 4.068e-07 0 4.06805e-07 0.9 4.164e-07 0.9 4.16405e-07 0 4.179e-07 0 4.17905e-07 0.9 4.182e-07 0.9 4.18205e-07 0 4.185e-07 0 4.18505e-07 0.9 4.188e-07 0.9 4.18805e-07 0 4.191e-07 0 4.19105e-07 0.9 4.194e-07 0.9 4.19405e-07 0 4.197e-07 0 4.19705e-07 0.9 4.2e-07 0.9 4.20005e-07 0 4.203e-07 0 4.20305e-07 0.9 4.206e-07 0.9 4.20605e-07 0 4.209e-07 0 4.20905e-07 0.9 4.212e-07 0.9 4.21205e-07 0 4.221e-07 0 4.22105e-07 0.9 4.224e-07 0.9 4.22405e-07 0 4.227e-07 0 4.22705e-07 0.9 4.23e-07 0.9 4.23005e-07 0 4.233e-07 0 4.23305e-07 0.9 4.236e-07 0.9 4.23605e-07 0 4.239e-07 0 4.23905e-07 0.9 4.242e-07 0.9 4.24205e-07 0 4.245e-07 0 4.24505e-07 0.9 4.248e-07 0.9 4.24805e-07 0 4.251e-07 0 4.25105e-07 0.9 4.254e-07 0.9 4.25405e-07 0 4.257e-07 0 4.25705e-07 0.9 4.26e-07 0.9 4.26005e-07 0 4.263e-07 0 4.26305e-07 0.9 4.266e-07 0.9 4.26605e-07 0 4.269e-07 0 4.26905e-07 0.9 4.272e-07 0.9 4.27205e-07 0 4.275e-07 0 4.27505e-07 0.9 4.278e-07 0.9 4.27805e-07 0 4.281e-07 0 4.28105e-07 0.9 4.284e-07 0.9 4.28405e-07 0 4.287e-07 0 4.28705e-07 0.9 4.383e-07 0.9 4.38305e-07 0 4.398e-07 0 4.39805e-07 0.9 4.401e-07 0.9 4.40105e-07 0 4.404e-07 0 4.40405e-07 0.9 4.407e-07 0.9 4.40705e-07 0 4.41e-07 0 4.41005e-07 0.9 4.413e-07 0.9 4.41305e-07 0 4.416e-07 0 4.41605e-07 0.9 4.419e-07 0.9 4.41905e-07 0 4.422e-07 0 4.42205e-07 0.9 4.425e-07 0.9 4.42505e-07 0 4.428e-07 0 4.42805e-07 0.9 4.431e-07 0.9 4.43105e-07 0 4.44e-07 0 4.44005e-07 0.9 4.443e-07 0.9 4.44305e-07 0 4.446e-07 0 4.44605e-07 0.9 4.449e-07 0.9 4.44905e-07 0 4.452e-07 0 4.45205e-07 0.9 4.455e-07 0.9 4.45505e-07 0 4.458e-07 0 4.45805e-07 0.9 4.461e-07 0.9 4.46105e-07 0 4.464e-07 0 4.46405e-07 0.9 4.467e-07 0.9 4.46705e-07 0 4.47e-07 0 4.47005e-07 0.9 4.473e-07 0.9 4.47305e-07 0 4.476e-07 0 4.47605e-07 0.9 4.479e-07 0.9 4.47905e-07 0 4.482e-07 0 4.48205e-07 0.9 4.485e-07 0.9 4.48505e-07 0 4.488e-07 0 4.48805e-07 0.9 4.491e-07 0.9 4.49105e-07 0 4.494e-07 0 4.49405e-07 0.9 4.497e-07 0.9 4.49705e-07 0 4.5e-07 0 4.50005e-07 0.9 4.503e-07 0.9 4.50305e-07 0 4.506e-07 0 4.50605e-07 0.9 4.602e-07 0.9 4.60205e-07 0 4.617e-07 0 4.61705e-07 0.9 4.62e-07 0.9 4.62005e-07 0 4.623e-07 0 4.62305e-07 0.9 4.626e-07 0.9 4.62605e-07 0 4.629e-07 0 4.62905e-07 0.9 4.632e-07 0.9 4.63205e-07 0 4.635e-07 0 4.63505e-07 0.9 4.638e-07 0.9 4.63805e-07 0 4.641e-07 0 4.64105e-07 0.9 4.644e-07 0.9 4.64405e-07 0 4.647e-07 0 4.64705e-07 0.9 4.65e-07 0.9 4.65005e-07 0 4.659e-07 0 4.65905e-07 0.9 4.662e-07 0.9 4.66205e-07 0 4.665e-07 0 4.66505e-07 0.9 4.668e-07 0.9 4.66805e-07 0 4.671e-07 0 4.67105e-07 0.9 4.674e-07 0.9 4.67405e-07 0 4.677e-07 0 4.67705e-07 0.9 4.68e-07 0.9 4.68005e-07 0 4.683e-07 0 4.68305e-07 0.9 4.686e-07 0.9 4.68605e-07 0 4.689e-07 0 4.68905e-07 0.9 4.692e-07 0.9 4.69205e-07 0 4.695e-07 0 4.69505e-07 0.9 4.698e-07 0.9 4.69805e-07 0 4.701e-07 0 4.70105e-07 0.9 4.704e-07 0.9 4.70405e-07 0 4.707e-07 0 4.70705e-07 0.9 4.71e-07 0.9 4.71005e-07 0 4.713e-07 0 4.71305e-07 0.9 4.716e-07 0.9 4.71605e-07 0 4.719e-07 0 4.71905e-07 0.9 4.722e-07 0.9 4.72205e-07 0 4.725e-07 0 4.72505e-07 0.9 4.821e-07 0.9 4.82105e-07 0 4.836e-07 0 4.83605e-07 0.9 4.839e-07 0.9 4.83905e-07 0 4.842e-07 0 4.84205e-07 0.9 4.845e-07 0.9 4.84505e-07 0 4.848e-07 0 4.84805e-07 0.9 4.851e-07 0.9 4.85105e-07 0 4.854e-07 0 4.85405e-07 0.9 4.857e-07 0.9 4.85705e-07 0 4.86e-07 0 4.86005e-07 0.9 4.863e-07 0.9 4.86305e-07 0 4.866e-07 0 4.86605e-07 0.9 4.869e-07 0.9 4.86905e-07 0 4.878e-07 0 4.87805e-07 0.9 4.881e-07 0.9 4.88105e-07 0 4.884e-07 0 4.88405e-07 0.9 4.887e-07 0.9 4.88705e-07 0 4.89e-07 0 4.89005e-07 0.9 4.893e-07 0.9 4.89305e-07 0 4.896e-07 0 4.89605e-07 0.9 4.899e-07 0.9 4.89905e-07 0 4.902e-07 0 4.90205e-07 0.9 4.905e-07 0.9 4.90505e-07 0 4.908e-07 0 4.90805e-07 0.9 4.911e-07 0.9 4.91105e-07 0 4.914e-07 0 4.91405e-07 0.9 4.917e-07 0.9 4.91705e-07 0 4.92e-07 0 4.92005e-07 0.9 4.923e-07 0.9 4.92305e-07 0 4.926e-07 0 4.92605e-07 0.9 4.929e-07 0.9 4.92905e-07 0 4.932e-07 0 4.93205e-07 0.9 4.935e-07 0.9 4.93505e-07 0 4.938e-07 0 4.93805e-07 0.9 4.941e-07 0.9 4.94105e-07 0 4.944e-07 0 4.94405e-07 0.9 5.04e-07 0.9 5.04005e-07 0 5.055e-07 0 5.05505e-07 0.9 5.058e-07 0.9 5.05805e-07 0 5.061e-07 0 5.06105e-07 0.9 5.064e-07 0.9 5.06405e-07 0 5.067e-07 0 5.06705e-07 0.9 5.07e-07 0.9 5.07005e-07 0 5.073e-07 0 5.07305e-07 0.9 5.076e-07 0.9 5.07605e-07 0 5.079e-07 0 5.07905e-07 0.9 5.082e-07 0.9 5.08205e-07 0 5.085e-07 0 5.08505e-07 0.9 5.088e-07 0.9 5.08805e-07 0 5.097e-07 0 5.09705e-07 0.9 5.1e-07 0.9 5.10005e-07 0 5.103e-07 0 5.10305e-07 0.9 5.106e-07 0.9 5.10605e-07 0 5.109e-07 0 5.10905e-07 0.9 5.112e-07 0.9 5.11205e-07 0 5.115e-07 0 5.11505e-07 0.9 5.118e-07 0.9 5.11805e-07 0 5.121e-07 0 5.12105e-07 0.9 5.124e-07 0.9 5.12405e-07 0 5.127e-07 0 5.12705e-07 0.9 5.13e-07 0.9 5.13005e-07 0 5.133e-07 0 5.13305e-07 0.9 5.136e-07 0.9 5.13605e-07 0 5.139e-07 0 5.13905e-07 0.9 5.142e-07 0.9 5.14205e-07 0 5.145e-07 0 5.14505e-07 0.9 5.148e-07 0.9 5.14805e-07 0 5.151e-07 0 5.15105e-07 0.9 5.154e-07 0.9 5.15405e-07 0 5.157e-07 0 5.15705e-07 0.9 5.16e-07 0.9 5.16005e-07 0 5.163e-07 0 5.16305e-07 0.9 5.259e-07 0.9 5.25905e-07 0 5.274e-07 0 5.27405e-07 0.9 5.277e-07 0.9 5.27705e-07 0 5.28e-07 0 5.28005e-07 0.9 5.283e-07 0.9 5.28305e-07 0 5.286e-07 0 5.28605e-07 0.9 5.289e-07 0.9 5.28905e-07 0 5.292e-07 0 5.29205e-07 0.9 5.295e-07 0.9 5.29505e-07 0 5.298e-07 0 5.29805e-07 0.9 5.301e-07 0.9 5.30105e-07 0 5.304e-07 0 5.30405e-07 0.9 5.307e-07 0.9 5.30705e-07 0 5.316e-07 0 5.31605e-07 0.9 5.319e-07 0.9 5.31905e-07 0 5.322e-07 0 5.32205e-07 0.9 5.325e-07 0.9 5.32505e-07 0 5.328e-07 0 5.32805e-07 0.9 5.331e-07 0.9 5.33105e-07 0 5.334e-07 0 5.33405e-07 0.9 5.337e-07 0.9 5.33705e-07 0 5.34e-07 0 5.34005e-07 0.9 5.343e-07 0.9 5.34305e-07 0 5.346e-07 0 5.34605e-07 0.9 5.349e-07 0.9 5.34905e-07 0 5.352e-07 0 5.35205e-07 0.9 5.355e-07 0.9 5.35505e-07 0 5.358e-07 0 5.35805e-07 0.9 5.361e-07 0.9 5.36105e-07 0 5.364e-07 0 5.36405e-07 0.9 5.367e-07 0.9 5.36705e-07 0 5.37e-07 0 5.37005e-07 0.9 5.373e-07 0.9 5.37305e-07 0 5.376e-07 0 5.37605e-07 0.9 5.379e-07 0.9 5.37905e-07 0 5.382e-07 0 5.38205e-07 0.9 5.478e-07 0.9 5.47805e-07 0 5.493e-07 0 5.49305e-07 0.9 5.496e-07 0.9 5.49605e-07 0 5.499e-07 0 5.49905e-07 0.9 5.502e-07 0.9 5.50205e-07 0 5.505e-07 0 5.50505e-07 0.9 5.508e-07 0.9 5.50805e-07 0 5.511e-07 0 5.51105e-07 0.9 5.514e-07 0.9 5.51405e-07 0 5.517e-07 0 5.51705e-07 0.9 5.52e-07 0.9 5.52005e-07 0 5.523e-07 0 5.52305e-07 0.9 5.526e-07 0.9 5.52605e-07 0 5.535e-07 0 5.53505e-07 0.9 5.538e-07 0.9 5.53805e-07 0 5.541e-07 0 5.54105e-07 0.9 5.544e-07 0.9 5.54405e-07 0 5.547e-07 0 5.54705e-07 0.9 5.55e-07 0.9 5.55005e-07 0 5.553e-07 0 5.55305e-07 0.9 5.556e-07 0.9 5.55605e-07 0 5.559e-07 0 5.55905e-07 0.9 5.562e-07 0.9 5.56205e-07 0 5.565e-07 0 5.56505e-07 0.9 5.568e-07 0.9 5.56805e-07 0 5.571e-07 0 5.57105e-07 0.9 5.574e-07 0.9 5.57405e-07 0 5.577e-07 0 5.57705e-07 0.9 5.58e-07 0.9 5.58005e-07 0 5.583e-07 0 5.58305e-07 0.9 5.586e-07 0.9 5.58605e-07 0 5.589e-07 0 5.58905e-07 0.9 5.592e-07 0.9 5.59205e-07 0 5.595e-07 0 5.59505e-07 0.9 5.598e-07 0.9 5.59805e-07 0 5.601e-07 0 5.60105e-07 0.9 5.697e-07 0.9 5.69705e-07 0 5.712e-07 0 5.71205e-07 0.9 5.715e-07 0.9 5.71505e-07 0 5.718e-07 0 5.71805e-07 0.9 5.721e-07 0.9 5.72105e-07 0 5.724e-07 0 5.72405e-07 0.9 5.727e-07 0.9 5.72705e-07 0 5.73e-07 0 5.73005e-07 0.9 5.733e-07 0.9 5.73305e-07 0 5.736e-07 0 5.73605e-07 0.9 5.739e-07 0.9 5.73905e-07 0 5.742e-07 0 5.74205e-07 0.9 5.745e-07 0.9 5.74505e-07 0 5.754e-07 0 5.75405e-07 0.9 5.757e-07 0.9 5.75705e-07 0 5.76e-07 0 5.76005e-07 0.9 5.763e-07 0.9 5.76305e-07 0 5.766e-07 0 5.76605e-07 0.9 5.769e-07 0.9 5.76905e-07 0 5.772e-07 0 5.77205e-07 0.9 5.775e-07 0.9 5.77505e-07 0 5.778e-07 0 5.77805e-07 0.9 5.781e-07 0.9 5.78105e-07 0 5.784e-07 0 5.78405e-07 0.9 5.787e-07 0.9 5.78705e-07 0 5.79e-07 0 5.79005e-07 0.9 5.793e-07 0.9 5.79305e-07 0 5.796e-07 0 5.79605e-07 0.9 5.799e-07 0.9 5.79905e-07 0 5.802e-07 0 5.80205e-07 0.9 5.805e-07 0.9 5.80505e-07 0 5.808e-07 0 5.80805e-07 0.9 5.811e-07 0.9 5.81105e-07 0 5.814e-07 0 5.81405e-07 0.9 5.817e-07 0.9 5.81705e-07 0 5.82e-07 0 5.82005e-07 0.9]
MDN1 (i1 src1 0 0) nmos_rvt l=20n nfin=1
MDP1 (i1 src1 vdd vdd) pmos_rvt l=20n nfin=2
VS2 (src2 0) vsource type=pwl wave=[0 0.9 3e-10 0.9 3.05e-10 0 1.2e-09 0 1.205e-09 0.9 1.5e-09 0.9 1.505e-09 0 3e-09 0 3.005e-09 0.9 3.3e-09 0.9 3.305e-09 0 4.8e-09 0 4.805e-09 0.9 5.1e-09 0.9 5.105e-09 0 5.4e-09 0 5.405e-09 0.9 5.7e-09 0.9 5.705e-09 0 7.2e-09 0 7.205e-09 0.9 7.5e-09 0.9 7.505e-09 0 9e-09 0 9.005e-09 0.9 9.6e-09 0.9 9.605e-09 0 9.9e-09 0 9.905e-09 0.9 1.02e-08 0.9 1.0205e-08 0 1.05e-08 0 1.0505e-08 0.9 1.14e-08 0.9 1.1405e-08 0 1.17e-08 0 1.1705e-08 0.9 1.2e-08 0.9 1.2005e-08 0 1.23e-08 0 1.2305e-08 0.9 1.29e-08 0.9 1.2905e-08 0 1.38e-08 0 1.3805e-08 0.9 1.41e-08 0.9 1.4105e-08 0 1.56e-08 0 1.5605e-08 0.9 1.59e-08 0.9 1.5905e-08 0 1.62e-08 0 1.6205e-08 0.9 1.65e-08 0.9 1.6505e-08 0 1.8e-08 0 1.8005e-08 0.9 1.86e-08 0.9 1.8605e-08 0 1.89e-08 0 1.8905e-08 0.9 1.92e-08 0.9 1.9205e-08 0 1.95e-08 0 1.9505e-08 0.9 2.01e-08 0.9 2.0105e-08 0 2.1e-08 0 2.1005e-08 0.9 2.13e-08 0.9 2.1305e-08 0 2.16e-08 0 2.1605e-08 0.9 2.22e-08 0.9 2.2205e-08 0 2.31e-08 0 2.3105e-08 0.9 2.34e-08 0.9 2.3405e-08 0 2.49e-08 0 2.4905e-08 0.9 2.52e-08 0.9 2.5205e-08 0 2.67e-08 0 2.6705e-08 0.9 2.7e-08 0.9 2.7005e-08 0 2.73e-08 0 2.7305e-08 0.9 2.76e-08 0.9 2.7605e-08 0 2.91e-08 0 2.9105e-08 0.9 2.94e-08 0.9 2.9405e-08 0 3.09e-08 0 3.0905e-08 0.9 3.15e-08 0.9 3.1505e-08 0 3.18e-08 0 3.1805e-08 0.9 3.21e-08 0.9 3.2105e-08 0 3.24e-08 0 3.2405e-08 0.9 3.33e-08 0.9 3.3305e-08 0 3.36e-08 0 3.3605e-08 0.9 3.39e-08 0.9 3.3905e-08 0 3.42e-08 0 3.4205e-08 0.9 3.48e-08 0.9 3.4805e-08 0 3.57e-08 0 3.5705e-08 0.9 3.6e-08 0.9 3.6005e-08 0 3.75e-08 0 3.7505e-08 0.9 3.78e-08 0.9 3.7805e-08 0 3.81e-08 0 3.8105e-08 0.9 3.84e-08 0.9 3.8405e-08 0 3.99e-08 0 3.9905e-08 0.9 4.05e-08 0.9 4.0505e-08 0 4.08e-08 0 4.0805e-08 0.9 4.11e-08 0.9 4.1105e-08 0 4.14e-08 0 4.1405e-08 0.9 4.2e-08 0.9 4.2005e-08 0 4.29e-08 0 4.2905e-08 0.9 4.32e-08 0.9 4.3205e-08 0 4.35e-08 0 4.3505e-08 0.9 4.41e-08 0.9 4.4105e-08 0 4.5e-08 0 4.5005e-08 0.9 4.53e-08 0.9 4.5305e-08 0 4.68e-08 0 4.6805e-08 0.9 4.71e-08 0.9 4.7105e-08 0 4.86e-08 0 4.8605e-08 0.9 4.89e-08 0.9 4.8905e-08 0 4.92e-08 0 4.9205e-08 0.9 4.95e-08 0.9 4.9505e-08 0 5.1e-08 0 5.1005e-08 0.9 5.13e-08 0.9 5.1305e-08 0 5.28e-08 0 5.2805e-08 0.9 5.34e-08 0.9 5.3405e-08 0 5.37e-08 0 5.3705e-08 0.9 5.4e-08 0.9 5.4005e-08 0 5.43e-08 0 5.4305e-08 0.9 5.52e-08 0.9 5.5205e-08 0 5.55e-08 0 5.5505e-08 0.9 5.58e-08 0.9 5.5805e-08 0 5.61e-08 0 5.6105e-08 0.9 5.67e-08 0.9 5.6705e-08 0 5.76e-08 0 5.7605e-08 0.9 5.79e-08 0.9 5.7905e-08 0 5.94e-08 0 5.9405e-08 0.9 5.97e-08 0.9 5.9705e-08 0 6e-08 0 6.0005e-08 0.9 6.03e-08 0.9 6.0305e-08 0 6.18e-08 0 6.1805e-08 0.9 6.24e-08 0.9 6.2405e-08 0 6.27e-08 0 6.2705e-08 0.9 6.3e-08 0.9 6.3005e-08 0 6.33e-08 0 6.3305e-08 0.9 6.39e-08 0.9 6.3905e-08 0 6.48e-08 0 6.4805e-08 0.9 6.51e-08 0.9 6.5105e-08 0 6.54e-08 0 6.5405e-08 0.9 6.6e-08 0.9 6.6005e-08 0 6.69e-08 0 6.6905e-08 0.9 6.72e-08 0.9 6.7205e-08 0 6.87e-08 0 6.8705e-08 0.9 6.9e-08 0.9 6.9005e-08 0 7.05e-08 0 7.0505e-08 0.9 7.08e-08 0.9 7.0805e-08 0 7.11e-08 0 7.1105e-08 0.9 7.14e-08 0.9 7.1405e-08 0 7.29e-08 0 7.2905e-08 0.9 7.32e-08 0.9 7.3205e-08 0 7.47e-08 0 7.4705e-08 0.9 7.53e-08 0.9 7.5305e-08 0 7.56e-08 0 7.5605e-08 0.9 7.59e-08 0.9 7.5905e-08 0 7.62e-08 0 7.6205e-08 0.9 7.71e-08 0.9 7.7105e-08 0 7.74e-08 0 7.7405e-08 0.9 7.77e-08 0.9 7.7705e-08 0 7.8e-08 0 7.8005e-08 0.9 7.86e-08 0.9 7.8605e-08 0 7.95e-08 0 7.9505e-08 0.9 7.98e-08 0.9 7.9805e-08 0 8.13e-08 0 8.1305e-08 0.9 8.16e-08 0.9 8.1605e-08 0 8.19e-08 0 8.1905e-08 0.9 8.22e-08 0.9 8.2205e-08 0 8.37e-08 0 8.3705e-08 0.9 8.43e-08 0.9 8.4305e-08 0 8.46e-08 0 8.4605e-08 0.9 8.49e-08 0.9 8.4905e-08 0 8.52e-08 0 8.5205e-08 0.9 8.58e-08 0.9 8.5805e-08 0 8.67e-08 0 8.6705e-08 0.9 8.7e-08 0.9 8.7005e-08 0 8.73e-08 0 8.7305e-08 0.9 8.79e-08 0.9 8.7905e-08 0 8.88e-08 0 8.8805e-08 0.9 8.91e-08 0.9 8.9105e-08 0 9.06e-08 0 9.0605e-08 0.9 9.09e-08 0.9 9.0905e-08 0 9.24e-08 0 9.2405e-08 0.9 9.27e-08 0.9 9.2705e-08 0 9.3e-08 0 9.3005e-08 0.9 9.33e-08 0.9 9.3305e-08 0 9.48e-08 0 9.4805e-08 0.9 9.51e-08 0.9 9.5105e-08 0 9.66e-08 0 9.6605e-08 0.9 9.72e-08 0.9 9.7205e-08 0 9.75e-08 0 9.7505e-08 0.9 9.78e-08 0.9 9.7805e-08 0 9.81e-08 0 9.8105e-08 0.9 9.9e-08 0.9 9.9005e-08 0 9.93e-08 0 9.9305e-08 0.9 9.96e-08 0.9 9.9605e-08 0 9.99e-08 0 9.9905e-08 0.9 1.005e-07 0.9 1.00505e-07 0 1.014e-07 0 1.01405e-07 0.9 1.017e-07 0.9 1.01705e-07 0 1.032e-07 0 1.03205e-07 0.9 1.035e-07 0.9 1.03505e-07 0 1.038e-07 0 1.03805e-07 0.9 1.041e-07 0.9 1.04105e-07 0 1.056e-07 0 1.05605e-07 0.9 1.062e-07 0.9 1.06205e-07 0 1.065e-07 0 1.06505e-07 0.9 1.068e-07 0.9 1.06805e-07 0 1.071e-07 0 1.07105e-07 0.9 1.077e-07 0.9 1.07705e-07 0 1.086e-07 0 1.08605e-07 0.9 1.089e-07 0.9 1.08905e-07 0 1.092e-07 0 1.09205e-07 0.9 1.098e-07 0.9 1.09805e-07 0 1.107e-07 0 1.10705e-07 0.9 1.11e-07 0.9 1.11005e-07 0 1.125e-07 0 1.12505e-07 0.9 1.128e-07 0.9 1.12805e-07 0 1.143e-07 0 1.14305e-07 0.9 1.146e-07 0.9 1.14605e-07 0 1.149e-07 0 1.14905e-07 0.9 1.152e-07 0.9 1.15205e-07 0 1.167e-07 0 1.16705e-07 0.9 1.17e-07 0.9 1.17005e-07 0 1.185e-07 0 1.18505e-07 0.9 1.191e-07 0.9 1.19105e-07 0 1.194e-07 0 1.19405e-07 0.9 1.197e-07 0.9 1.19705e-07 0 1.2e-07 0 1.20005e-07 0.9 1.209e-07 0.9 1.20905e-07 0 1.212e-07 0 1.21205e-07 0.9 1.215e-07 0.9 1.21505e-07 0 1.218e-07 0 1.21805e-07 0.9 1.224e-07 0.9 1.22405e-07 0 1.233e-07 0 1.23305e-07 0.9 1.236e-07 0.9 1.23605e-07 0 1.251e-07 0 1.25105e-07 0.9 1.254e-07 0.9 1.25405e-07 0 1.257e-07 0 1.25705e-07 0.9 1.26e-07 0.9 1.26005e-07 0 1.275e-07 0 1.27505e-07 0.9 1.281e-07 0.9 1.28105e-07 0 1.284e-07 0 1.28405e-07 0.9 1.287e-07 0.9 1.28705e-07 0 1.29e-07 0 1.29005e-07 0.9 1.296e-07 0.9 1.29605e-07 0 1.305e-07 0 1.30505e-07 0.9 1.308e-07 0.9 1.30805e-07 0 1.311e-07 0 1.31105e-07 0.9 1.317e-07 0.9 1.31705e-07 0 1.326e-07 0 1.32605e-07 0.9 1.329e-07 0.9 1.32905e-07 0 1.344e-07 0 1.34405e-07 0.9 1.347e-07 0.9 1.34705e-07 0 1.362e-07 0 1.36205e-07 0.9 1.365e-07 0.9 1.36505e-07 0 1.368e-07 0 1.36805e-07 0.9 1.371e-07 0.9 1.37105e-07 0 1.386e-07 0 1.38605e-07 0.9 1.389e-07 0.9 1.38905e-07 0 1.404e-07 0 1.40405e-07 0.9 1.41e-07 0.9 1.41005e-07 0 1.413e-07 0 1.41305e-07 0.9 1.416e-07 0.9 1.41605e-07 0 1.419e-07 0 1.41905e-07 0.9 1.428e-07 0.9 1.42805e-07 0 1.431e-07 0 1.43105e-07 0.9 1.434e-07 0.9 1.43405e-07 0 1.437e-07 0 1.43705e-07 0.9 1.443e-07 0.9 1.44305e-07 0 1.452e-07 0 1.45205e-07 0.9 1.455e-07 0.9 1.45505e-07 0 1.47e-07 0 1.47005e-07 0.9 1.473e-07 0.9 1.47305e-07 0 1.476e-07 0 1.47605e-07 0.9 1.479e-07 0.9 1.47905e-07 0 1.494e-07 0 1.49405e-07 0.9 1.5e-07 0.9 1.50005e-07 0 1.503e-07 0 1.50305e-07 0.9 1.506e-07 0.9 1.50605e-07 0 1.509e-07 0 1.50905e-07 0.9 1.515e-07 0.9 1.51505e-07 0 1.524e-07 0 1.52405e-07 0.9 1.527e-07 0.9 1.52705e-07 0 1.53e-07 0 1.53005e-07 0.9 1.536e-07 0.9 1.53605e-07 0 1.545e-07 0 1.54505e-07 0.9 1.548e-07 0.9 1.54805e-07 0 1.563e-07 0 1.56305e-07 0.9 1.566e-07 0.9 1.56605e-07 0 1.581e-07 0 1.58105e-07 0.9 1.584e-07 0.9 1.58405e-07 0 1.587e-07 0 1.58705e-07 0.9 1.59e-07 0.9 1.59005e-07 0 1.605e-07 0 1.60505e-07 0.9 1.608e-07 0.9 1.60805e-07 0 1.623e-07 0 1.62305e-07 0.9 1.629e-07 0.9 1.62905e-07 0 1.632e-07 0 1.63205e-07 0.9 1.635e-07 0.9 1.63505e-07 0 1.638e-07 0 1.63805e-07 0.9 1.647e-07 0.9 1.64705e-07 0 1.65e-07 0 1.65005e-07 0.9 1.653e-07 0.9 1.65305e-07 0 1.656e-07 0 1.65605e-07 0.9 1.662e-07 0.9 1.66205e-07 0 1.671e-07 0 1.67105e-07 0.9 1.674e-07 0.9 1.67405e-07 0 1.689e-07 0 1.68905e-07 0.9 1.692e-07 0.9 1.69205e-07 0 1.695e-07 0 1.69505e-07 0.9 1.698e-07 0.9 1.69805e-07 0 1.713e-07 0 1.71305e-07 0.9 1.719e-07 0.9 1.71905e-07 0 1.722e-07 0 1.72205e-07 0.9 1.725e-07 0.9 1.72505e-07 0 1.728e-07 0 1.72805e-07 0.9 1.734e-07 0.9 1.73405e-07 0 1.743e-07 0 1.74305e-07 0.9 1.746e-07 0.9 1.74605e-07 0 1.749e-07 0 1.74905e-07 0.9 1.755e-07 0.9 1.75505e-07 0 1.764e-07 0 1.76405e-07 0.9 1.767e-07 0.9 1.76705e-07 0 1.782e-07 0 1.78205e-07 0.9 1.785e-07 0.9 1.78505e-07 0 1.8e-07 0 1.80005e-07 0.9 1.803e-07 0.9 1.80305e-07 0 1.806e-07 0 1.80605e-07 0.9 1.809e-07 0.9 1.80905e-07 0 1.824e-07 0 1.82405e-07 0.9 1.827e-07 0.9 1.82705e-07 0 1.842e-07 0 1.84205e-07 0.9 1.848e-07 0.9 1.84805e-07 0 1.851e-07 0 1.85105e-07 0.9 1.854e-07 0.9 1.85405e-07 0 1.857e-07 0 1.85705e-07 0.9 1.866e-07 0.9 1.86605e-07 0 1.869e-07 0 1.86905e-07 0.9 1.872e-07 0.9 1.87205e-07 0 1.875e-07 0 1.87505e-07 0.9 1.881e-07 0.9 1.88105e-07 0 1.89e-07 0 1.89005e-07 0.9 1.893e-07 0.9 1.89305e-07 0 1.908e-07 0 1.90805e-07 0.9 1.911e-07 0.9 1.91105e-07 0 1.914e-07 0 1.91405e-07 0.9 1.917e-07 0.9 1.91705e-07 0 1.932e-07 0 1.93205e-07 0.9 1.938e-07 0.9 1.93805e-07 0 1.941e-07 0 1.94105e-07 0.9 1.944e-07 0.9 1.94405e-07 0 1.947e-07 0 1.94705e-07 0.9 1.953e-07 0.9 1.95305e-07 0 1.962e-07 0 1.96205e-07 0.9 1.965e-07 0.9 1.96505e-07 0 1.968e-07 0 1.96805e-07 0.9 1.974e-07 0.9 1.97405e-07 0 1.983e-07 0 1.98305e-07 0.9 1.986e-07 0.9 1.98605e-07 0 2.001e-07 0 2.00105e-07 0.9 2.004e-07 0.9 2.00405e-07 0 2.019e-07 0 2.01905e-07 0.9 2.022e-07 0.9 2.02205e-07 0 2.025e-07 0 2.02505e-07 0.9 2.028e-07 0.9 2.02805e-07 0 2.043e-07 0 2.04305e-07 0.9 2.046e-07 0.9 2.04605e-07 0 2.061e-07 0 2.06105e-07 0.9 2.067e-07 0.9 2.06705e-07 0 2.07e-07 0 2.07005e-07 0.9 2.073e-07 0.9 2.07305e-07 0 2.076e-07 0 2.07605e-07 0.9 2.085e-07 0.9 2.08505e-07 0 2.088e-07 0 2.08805e-07 0.9 2.091e-07 0.9 2.09105e-07 0 2.094e-07 0 2.09405e-07 0.9 2.1e-07 0.9 2.10005e-07 0 2.109e-07 0 2.10905e-07 0.9 2.112e-07 0.9 2.11205e-07 0 2.127e-07 0 2.12705e-07 0.9 2.13e-07 0.9 2.13005e-07 0 2.133e-07 0 2.13305e-07 0.9 2.136e-07 0.9 2.13605e-07 0 2.151e-07 0 2.15105e-07 0.9 2.157e-07 0.9 2.15705e-07 0 2.16e-07 0 2.16005e-07 0.9 2.163e-07 0.9 2.16305e-07 0 2.166e-07 0 2.16605e-07 0.9 2.172e-07 0.9 2.17205e-07 0 2.181e-07 0 2.18105e-07 0.9 2.184e-07 0.9 2.18405e-07 0 2.187e-07 0 2.18705e-07 0.9 2.193e-07 0.9 2.19305e-07 0 2.202e-07 0 2.20205e-07 0.9 2.205e-07 0.9 2.20505e-07 0 2.22e-07 0 2.22005e-07 0.9 2.223e-07 0.9 2.22305e-07 0 2.238e-07 0 2.23805e-07 0.9 2.241e-07 0.9 2.24105e-07 0 2.244e-07 0 2.24405e-07 0.9 2.247e-07 0.9 2.24705e-07 0 2.262e-07 0 2.26205e-07 0.9 2.265e-07 0.9 2.26505e-07 0 2.28e-07 0 2.28005e-07 0.9 2.286e-07 0.9 2.28605e-07 0 2.289e-07 0 2.28905e-07 0.9 2.292e-07 0.9 2.29205e-07 0 2.295e-07 0 2.29505e-07 0.9 2.304e-07 0.9 2.30405e-07 0 2.307e-07 0 2.30705e-07 0.9 2.31e-07 0.9 2.31005e-07 0 2.313e-07 0 2.31305e-07 0.9 2.319e-07 0.9 2.31905e-07 0 2.328e-07 0 2.32805e-07 0.9 2.331e-07 0.9 2.33105e-07 0 2.346e-07 0 2.34605e-07 0.9 2.349e-07 0.9 2.34905e-07 0 2.352e-07 0 2.35205e-07 0.9 2.355e-07 0.9 2.35505e-07 0 2.37e-07 0 2.37005e-07 0.9 2.376e-07 0.9 2.37605e-07 0 2.379e-07 0 2.37905e-07 0.9 2.382e-07 0.9 2.38205e-07 0 2.385e-07 0 2.38505e-07 0.9 2.391e-07 0.9 2.39105e-07 0 2.4e-07 0 2.40005e-07 0.9 2.403e-07 0.9 2.40305e-07 0 2.406e-07 0 2.40605e-07 0.9 2.412e-07 0.9 2.41205e-07 0 2.421e-07 0 2.42105e-07 0.9 2.424e-07 0.9 2.42405e-07 0 2.439e-07 0 2.43905e-07 0.9 2.442e-07 0.9 2.44205e-07 0 2.457e-07 0 2.45705e-07 0.9 2.46e-07 0.9 2.46005e-07 0 2.463e-07 0 2.46305e-07 0.9 2.466e-07 0.9 2.46605e-07 0 2.481e-07 0 2.48105e-07 0.9 2.484e-07 0.9 2.48405e-07 0 2.499e-07 0 2.49905e-07 0.9 2.505e-07 0.9 2.50505e-07 0 2.508e-07 0 2.50805e-07 0.9 2.511e-07 0.9 2.51105e-07 0 2.514e-07 0 2.51405e-07 0.9 2.523e-07 0.9 2.52305e-07 0 2.526e-07 0 2.52605e-07 0.9 2.529e-07 0.9 2.52905e-07 0 2.532e-07 0 2.53205e-07 0.9 2.538e-07 0.9 2.53805e-07 0 2.547e-07 0 2.54705e-07 0.9 2.55e-07 0.9 2.55005e-07 0 2.565e-07 0 2.56505e-07 0.9 2.568e-07 0.9 2.56805e-07 0 2.571e-07 0 2.57105e-07 0.9 2.574e-07 0.9 2.57405e-07 0 2.589e-07 0 2.58905e-07 0.9 2.595e-07 0.9 2.59505e-07 0 2.598e-07 0 2.59805e-07 0.9 2.601e-07 0.9 2.60105e-07 0 2.604e-07 0 2.60405e-07 0.9 2.61e-07 0.9 2.61005e-07 0 2.619e-07 0 2.61905e-07 0.9 2.622e-07 0.9 2.62205e-07 0 2.625e-07 0 2.62505e-07 0.9 2.631e-07 0.9 2.63105e-07 0 2.64e-07 0 2.64005e-07 0.9 2.643e-07 0.9 2.64305e-07 0 2.658e-07 0 2.65805e-07 0.9 2.661e-07 0.9 2.66105e-07 0 2.676e-07 0 2.67605e-07 0.9 2.679e-07 0.9 2.67905e-07 0 2.682e-07 0 2.68205e-07 0.9 2.685e-07 0.9 2.68505e-07 0 2.7e-07 0 2.70005e-07 0.9 2.703e-07 0.9 2.70305e-07 0 2.718e-07 0 2.71805e-07 0.9 2.724e-07 0.9 2.72405e-07 0 2.727e-07 0 2.72705e-07 0.9 2.73e-07 0.9 2.73005e-07 0 2.733e-07 0 2.73305e-07 0.9 2.742e-07 0.9 2.74205e-07 0 2.745e-07 0 2.74505e-07 0.9 2.748e-07 0.9 2.74805e-07 0 2.751e-07 0 2.75105e-07 0.9 2.757e-07 0.9 2.75705e-07 0 2.766e-07 0 2.76605e-07 0.9 2.769e-07 0.9 2.76905e-07 0 2.784e-07 0 2.78405e-07 0.9 2.787e-07 0.9 2.78705e-07 0 2.79e-07 0 2.79005e-07 0.9 2.793e-07 0.9 2.79305e-07 0 2.808e-07 0 2.80805e-07 0.9 2.814e-07 0.9 2.81405e-07 0 2.817e-07 0 2.81705e-07 0.9 2.82e-07 0.9 2.82005e-07 0 2.823e-07 0 2.82305e-07 0.9 2.829e-07 0.9 2.82905e-07 0 2.838e-07 0 2.83805e-07 0.9 2.841e-07 0.9 2.84105e-07 0 2.844e-07 0 2.84405e-07 0.9 2.85e-07 0.9 2.85005e-07 0 2.859e-07 0 2.85905e-07 0.9 2.862e-07 0.9 2.86205e-07 0 2.877e-07 0 2.87705e-07 0.9 2.88e-07 0.9 2.88005e-07 0 2.895e-07 0 2.89505e-07 0.9 2.898e-07 0.9 2.89805e-07 0 2.901e-07 0 2.90105e-07 0.9 2.904e-07 0.9 2.90405e-07 0 2.919e-07 0 2.91905e-07 0.9 2.922e-07 0.9 2.92205e-07 0 2.937e-07 0 2.93705e-07 0.9 2.943e-07 0.9 2.94305e-07 0 2.946e-07 0 2.94605e-07 0.9 2.949e-07 0.9 2.94905e-07 0 2.952e-07 0 2.95205e-07 0.9 2.961e-07 0.9 2.96105e-07 0 2.964e-07 0 2.96405e-07 0.9 2.967e-07 0.9 2.96705e-07 0 2.97e-07 0 2.97005e-07 0.9 2.976e-07 0.9 2.97605e-07 0 2.985e-07 0 2.98505e-07 0.9 2.988e-07 0.9 2.98805e-07 0 3.003e-07 0 3.00305e-07 0.9 3.006e-07 0.9 3.00605e-07 0 3.009e-07 0 3.00905e-07 0.9 3.012e-07 0.9 3.01205e-07 0 3.027e-07 0 3.02705e-07 0.9 3.033e-07 0.9 3.03305e-07 0 3.036e-07 0 3.03605e-07 0.9 3.039e-07 0.9 3.03905e-07 0 3.042e-07 0 3.04205e-07 0.9 3.048e-07 0.9 3.04805e-07 0 3.057e-07 0 3.05705e-07 0.9 3.06e-07 0.9 3.06005e-07 0 3.063e-07 0 3.06305e-07 0.9 3.069e-07 0.9 3.06905e-07 0 3.078e-07 0 3.07805e-07 0.9 3.081e-07 0.9 3.08105e-07 0 3.096e-07 0 3.09605e-07 0.9 3.099e-07 0.9 3.09905e-07 0 3.114e-07 0 3.11405e-07 0.9 3.117e-07 0.9 3.11705e-07 0 3.12e-07 0 3.12005e-07 0.9 3.123e-07 0.9 3.12305e-07 0 3.138e-07 0 3.13805e-07 0.9 3.141e-07 0.9 3.14105e-07 0 3.156e-07 0 3.15605e-07 0.9 3.162e-07 0.9 3.16205e-07 0 3.165e-07 0 3.16505e-07 0.9 3.168e-07 0.9 3.16805e-07 0 3.171e-07 0 3.17105e-07 0.9 3.18e-07 0.9 3.18005e-07 0 3.183e-07 0 3.18305e-07 0.9 3.186e-07 0.9 3.18605e-07 0 3.189e-07 0 3.18905e-07 0.9 3.195e-07 0.9 3.19505e-07 0 3.204e-07 0 3.20405e-07 0.9 3.207e-07 0.9 3.20705e-07 0 3.222e-07 0 3.22205e-07 0.9 3.225e-07 0.9 3.22505e-07 0 3.228e-07 0 3.22805e-07 0.9 3.231e-07 0.9 3.23105e-07 0 3.246e-07 0 3.24605e-07 0.9 3.252e-07 0.9 3.25205e-07 0 3.255e-07 0 3.25505e-07 0.9 3.258e-07 0.9 3.25805e-07 0 3.261e-07 0 3.26105e-07 0.9 3.267e-07 0.9 3.26705e-07 0 3.276e-07 0 3.27605e-07 0.9 3.279e-07 0.9 3.27905e-07 0 3.282e-07 0 3.28205e-07 0.9 3.288e-07 0.9 3.28805e-07 0 3.297e-07 0 3.29705e-07 0.9 3.3e-07 0.9 3.30005e-07 0 3.315e-07 0 3.31505e-07 0.9 3.318e-07 0.9 3.31805e-07 0 3.333e-07 0 3.33305e-07 0.9 3.336e-07 0.9 3.33605e-07 0 3.339e-07 0 3.33905e-07 0.9 3.342e-07 0.9 3.34205e-07 0 3.357e-07 0 3.35705e-07 0.9 3.36e-07 0.9 3.36005e-07 0 3.375e-07 0 3.37505e-07 0.9 3.381e-07 0.9 3.38105e-07 0 3.384e-07 0 3.38405e-07 0.9 3.387e-07 0.9 3.38705e-07 0 3.39e-07 0 3.39005e-07 0.9 3.399e-07 0.9 3.39905e-07 0 3.402e-07 0 3.40205e-07 0.9 3.405e-07 0.9 3.40505e-07 0 3.408e-07 0 3.40805e-07 0.9 3.414e-07 0.9 3.41405e-07 0 3.423e-07 0 3.42305e-07 0.9 3.426e-07 0.9 3.42605e-07 0 3.441e-07 0 3.44105e-07 0.9 3.444e-07 0.9 3.44405e-07 0 3.447e-07 0 3.44705e-07 0.9 3.45e-07 0.9 3.45005e-07 0 3.465e-07 0 3.46505e-07 0.9 3.471e-07 0.9 3.47105e-07 0 3.474e-07 0 3.47405e-07 0.9 3.477e-07 0.9 3.47705e-07 0 3.48e-07 0 3.48005e-07 0.9 3.486e-07 0.9 3.48605e-07 0 3.495e-07 0 3.49505e-07 0.9 3.498e-07 0.9 3.49805e-07 0 3.501e-07 0 3.50105e-07 0.9 3.507e-07 0.9 3.50705e-07 0 3.516e-07 0 3.51605e-07 0.9 3.519e-07 0.9 3.51905e-07 0 3.534e-07 0 3.53405e-07 0.9 3.537e-07 0.9 3.53705e-07 0 3.552e-07 0 3.55205e-07 0.9 3.555e-07 0.9 3.55505e-07 0 3.558e-07 0 3.55805e-07 0.9 3.561e-07 0.9 3.56105e-07 0 3.576e-07 0 3.57605e-07 0.9 3.579e-07 0.9 3.57905e-07 0 3.594e-07 0 3.59405e-07 0.9 3.6e-07 0.9 3.60005e-07 0 3.603e-07 0 3.60305e-07 0.9 3.606e-07 0.9 3.60605e-07 0 3.609e-07 0 3.60905e-07 0.9 3.618e-07 0.9 3.61805e-07 0 3.621e-07 0 3.62105e-07 0.9 3.624e-07 0.9 3.62405e-07 0 3.627e-07 0 3.62705e-07 0.9 3.633e-07 0.9 3.63305e-07 0 3.642e-07 0 3.64205e-07 0.9 3.645e-07 0.9 3.64505e-07 0 3.66e-07 0 3.66005e-07 0.9 3.663e-07 0.9 3.66305e-07 0 3.666e-07 0 3.66605e-07 0.9 3.669e-07 0.9 3.66905e-07 0 3.684e-07 0 3.68405e-07 0.9 3.69e-07 0.9 3.69005e-07 0 3.693e-07 0 3.69305e-07 0.9 3.696e-07 0.9 3.69605e-07 0 3.699e-07 0 3.69905e-07 0.9 3.705e-07 0.9 3.70505e-07 0 3.714e-07 0 3.71405e-07 0.9 3.717e-07 0.9 3.71705e-07 0 3.72e-07 0 3.72005e-07 0.9 3.726e-07 0.9 3.72605e-07 0 3.735e-07 0 3.73505e-07 0.9 3.738e-07 0.9 3.73805e-07 0 3.753e-07 0 3.75305e-07 0.9 3.756e-07 0.9 3.75605e-07 0 3.771e-07 0 3.77105e-07 0.9 3.774e-07 0.9 3.77405e-07 0 3.777e-07 0 3.77705e-07 0.9 3.78e-07 0.9 3.78005e-07 0 3.795e-07 0 3.79505e-07 0.9 3.798e-07 0.9 3.79805e-07 0 3.813e-07 0 3.81305e-07 0.9 3.819e-07 0.9 3.81905e-07 0 3.822e-07 0 3.82205e-07 0.9 3.825e-07 0.9 3.82505e-07 0 3.828e-07 0 3.82805e-07 0.9 3.837e-07 0.9 3.83705e-07 0 3.84e-07 0 3.84005e-07 0.9 3.843e-07 0.9 3.84305e-07 0 3.846e-07 0 3.84605e-07 0.9 3.852e-07 0.9 3.85205e-07 0 3.861e-07 0 3.86105e-07 0.9 3.864e-07 0.9 3.86405e-07 0 3.879e-07 0 3.87905e-07 0.9 3.882e-07 0.9 3.88205e-07 0 3.885e-07 0 3.88505e-07 0.9 3.888e-07 0.9 3.88805e-07 0 3.903e-07 0 3.90305e-07 0.9 3.909e-07 0.9 3.90905e-07 0 3.912e-07 0 3.91205e-07 0.9 3.915e-07 0.9 3.91505e-07 0 3.918e-07 0 3.91805e-07 0.9 3.924e-07 0.9 3.92405e-07 0 3.933e-07 0 3.93305e-07 0.9 3.936e-07 0.9 3.93605e-07 0 3.939e-07 0 3.93905e-07 0.9 3.945e-07 0.9 3.94505e-07 0 3.954e-07 0 3.95405e-07 0.9 3.957e-07 0.9 3.95705e-07 0 3.972e-07 0 3.97205e-07 0.9 3.975e-07 0.9 3.97505e-07 0 3.99e-07 0 3.99005e-07 0.9 3.993e-07 0.9 3.99305e-07 0 3.996e-07 0 3.99605e-07 0.9 3.999e-07 0.9 3.99905e-07 0 4.014e-07 0 4.01405e-07 0.9 4.017e-07 0.9 4.01705e-07 0 4.032e-07 0 4.03205e-07 0.9 4.038e-07 0.9 4.03805e-07 0 4.041e-07 0 4.04105e-07 0.9 4.044e-07 0.9 4.04405e-07 0 4.047e-07 0 4.04705e-07 0.9 4.056e-07 0.9 4.05605e-07 0 4.059e-07 0 4.05905e-07 0.9 4.062e-07 0.9 4.06205e-07 0 4.065e-07 0 4.06505e-07 0.9 4.071e-07 0.9 4.07105e-07 0 4.08e-07 0 4.08005e-07 0.9 4.083e-07 0.9 4.08305e-07 0 4.098e-07 0 4.09805e-07 0.9 4.101e-07 0.9 4.10105e-07 0 4.104e-07 0 4.10405e-07 0.9 4.107e-07 0.9 4.10705e-07 0 4.122e-07 0 4.12205e-07 0.9 4.128e-07 0.9 4.12805e-07 0 4.131e-07 0 4.13105e-07 0.9 4.134e-07 0.9 4.13405e-07 0 4.137e-07 0 4.13705e-07 0.9 4.143e-07 0.9 4.14305e-07 0 4.152e-07 0 4.15205e-07 0.9 4.155e-07 0.9 4.15505e-07 0 4.158e-07 0 4.15805e-07 0.9 4.164e-07 0.9 4.16405e-07 0 4.173e-07 0 4.17305e-07 0.9 4.176e-07 0.9 4.17605e-07 0 4.191e-07 0 4.19105e-07 0.9 4.194e-07 0.9 4.19405e-07 0 4.209e-07 0 4.20905e-07 0.9 4.212e-07 0.9 4.21205e-07 0 4.215e-07 0 4.21505e-07 0.9 4.218e-07 0.9 4.21805e-07 0 4.233e-07 0 4.23305e-07 0.9 4.236e-07 0.9 4.23605e-07 0 4.251e-07 0 4.25105e-07 0.9 4.257e-07 0.9 4.25705e-07 0 4.26e-07 0 4.26005e-07 0.9 4.263e-07 0.9 4.26305e-07 0 4.266e-07 0 4.26605e-07 0.9 4.275e-07 0.9 4.27505e-07 0 4.278e-07 0 4.27805e-07 0.9 4.281e-07 0.9 4.28105e-07 0 4.284e-07 0 4.28405e-07 0.9 4.29e-07 0.9 4.29005e-07 0 4.299e-07 0 4.29905e-07 0.9 4.302e-07 0.9 4.30205e-07 0 4.317e-07 0 4.31705e-07 0.9 4.32e-07 0.9 4.32005e-07 0 4.323e-07 0 4.32305e-07 0.9 4.326e-07 0.9 4.32605e-07 0 4.341e-07 0 4.34105e-07 0.9 4.347e-07 0.9 4.34705e-07 0 4.35e-07 0 4.35005e-07 0.9 4.353e-07 0.9 4.35305e-07 0 4.356e-07 0 4.35605e-07 0.9 4.362e-07 0.9 4.36205e-07 0 4.371e-07 0 4.37105e-07 0.9 4.374e-07 0.9 4.37405e-07 0 4.377e-07 0 4.37705e-07 0.9 4.383e-07 0.9 4.38305e-07 0 4.392e-07 0 4.39205e-07 0.9 4.395e-07 0.9 4.39505e-07 0 4.41e-07 0 4.41005e-07 0.9 4.413e-07 0.9 4.41305e-07 0 4.428e-07 0 4.42805e-07 0.9 4.431e-07 0.9 4.43105e-07 0 4.434e-07 0 4.43405e-07 0.9 4.437e-07 0.9 4.43705e-07 0 4.452e-07 0 4.45205e-07 0.9 4.455e-07 0.9 4.45505e-07 0 4.47e-07 0 4.47005e-07 0.9 4.476e-07 0.9 4.47605e-07 0 4.479e-07 0 4.47905e-07 0.9 4.482e-07 0.9 4.48205e-07 0 4.485e-07 0 4.48505e-07 0.9 4.494e-07 0.9 4.49405e-07 0 4.497e-07 0 4.49705e-07 0.9 4.5e-07 0.9 4.50005e-07 0 4.503e-07 0 4.50305e-07 0.9 4.509e-07 0.9 4.50905e-07 0 4.518e-07 0 4.51805e-07 0.9 4.521e-07 0.9 4.52105e-07 0 4.536e-07 0 4.53605e-07 0.9 4.539e-07 0.9 4.53905e-07 0 4.542e-07 0 4.54205e-07 0.9 4.545e-07 0.9 4.54505e-07 0 4.56e-07 0 4.56005e-07 0.9 4.566e-07 0.9 4.56605e-07 0 4.569e-07 0 4.56905e-07 0.9 4.572e-07 0.9 4.57205e-07 0 4.575e-07 0 4.57505e-07 0.9 4.581e-07 0.9 4.58105e-07 0 4.59e-07 0 4.59005e-07 0.9 4.593e-07 0.9 4.59305e-07 0 4.596e-07 0 4.59605e-07 0.9 4.602e-07 0.9 4.60205e-07 0 4.611e-07 0 4.61105e-07 0.9 4.614e-07 0.9 4.61405e-07 0 4.629e-07 0 4.62905e-07 0.9 4.632e-07 0.9 4.63205e-07 0 4.647e-07 0 4.64705e-07 0.9 4.65e-07 0.9 4.65005e-07 0 4.653e-07 0 4.65305e-07 0.9 4.656e-07 0.9 4.65605e-07 0 4.671e-07 0 4.67105e-07 0.9 4.674e-07 0.9 4.67405e-07 0 4.689e-07 0 4.68905e-07 0.9 4.695e-07 0.9 4.69505e-07 0 4.698e-07 0 4.69805e-07 0.9 4.701e-07 0.9 4.70105e-07 0 4.704e-07 0 4.70405e-07 0.9 4.713e-07 0.9 4.71305e-07 0 4.716e-07 0 4.71605e-07 0.9 4.719e-07 0.9 4.71905e-07 0 4.722e-07 0 4.72205e-07 0.9 4.728e-07 0.9 4.72805e-07 0 4.737e-07 0 4.73705e-07 0.9 4.74e-07 0.9 4.74005e-07 0 4.755e-07 0 4.75505e-07 0.9 4.758e-07 0.9 4.75805e-07 0 4.761e-07 0 4.76105e-07 0.9 4.764e-07 0.9 4.76405e-07 0 4.779e-07 0 4.77905e-07 0.9 4.785e-07 0.9 4.78505e-07 0 4.788e-07 0 4.78805e-07 0.9 4.791e-07 0.9 4.79105e-07 0 4.794e-07 0 4.79405e-07 0.9 4.8e-07 0.9 4.80005e-07 0 4.809e-07 0 4.80905e-07 0.9 4.812e-07 0.9 4.81205e-07 0 4.815e-07 0 4.81505e-07 0.9 4.821e-07 0.9 4.82105e-07 0 4.83e-07 0 4.83005e-07 0.9 4.833e-07 0.9 4.83305e-07 0 4.848e-07 0 4.84805e-07 0.9 4.851e-07 0.9 4.85105e-07 0 4.866e-07 0 4.86605e-07 0.9 4.869e-07 0.9 4.86905e-07 0 4.872e-07 0 4.87205e-07 0.9 4.875e-07 0.9 4.87505e-07 0 4.89e-07 0 4.89005e-07 0.9 4.893e-07 0.9 4.89305e-07 0 4.908e-07 0 4.90805e-07 0.9 4.914e-07 0.9 4.91405e-07 0 4.917e-07 0 4.91705e-07 0.9 4.92e-07 0.9 4.92005e-07 0 4.923e-07 0 4.92305e-07 0.9 4.932e-07 0.9 4.93205e-07 0 4.935e-07 0 4.93505e-07 0.9 4.938e-07 0.9 4.93805e-07 0 4.941e-07 0 4.94105e-07 0.9 4.947e-07 0.9 4.94705e-07 0 4.956e-07 0 4.95605e-07 0.9 4.959e-07 0.9 4.95905e-07 0 4.974e-07 0 4.97405e-07 0.9 4.977e-07 0.9 4.97705e-07 0 4.98e-07 0 4.98005e-07 0.9 4.983e-07 0.9 4.98305e-07 0 4.998e-07 0 4.99805e-07 0.9 5.004e-07 0.9 5.00405e-07 0 5.007e-07 0 5.00705e-07 0.9 5.01e-07 0.9 5.01005e-07 0 5.013e-07 0 5.01305e-07 0.9 5.019e-07 0.9 5.01905e-07 0 5.028e-07 0 5.02805e-07 0.9 5.031e-07 0.9 5.03105e-07 0 5.034e-07 0 5.03405e-07 0.9 5.04e-07 0.9 5.04005e-07 0 5.049e-07 0 5.04905e-07 0.9 5.052e-07 0.9 5.05205e-07 0 5.067e-07 0 5.06705e-07 0.9 5.07e-07 0.9 5.07005e-07 0 5.085e-07 0 5.08505e-07 0.9 5.088e-07 0.9 5.08805e-07 0 5.091e-07 0 5.09105e-07 0.9 5.094e-07 0.9 5.09405e-07 0 5.109e-07 0 5.10905e-07 0.9 5.112e-07 0.9 5.11205e-07 0 5.127e-07 0 5.12705e-07 0.9 5.133e-07 0.9 5.13305e-07 0 5.136e-07 0 5.13605e-07 0.9 5.139e-07 0.9 5.13905e-07 0 5.142e-07 0 5.14205e-07 0.9 5.151e-07 0.9 5.15105e-07 0 5.154e-07 0 5.15405e-07 0.9 5.157e-07 0.9 5.15705e-07 0 5.16e-07 0 5.16005e-07 0.9 5.166e-07 0.9 5.16605e-07 0 5.175e-07 0 5.17505e-07 0.9 5.178e-07 0.9 5.17805e-07 0 5.193e-07 0 5.19305e-07 0.9 5.196e-07 0.9 5.19605e-07 0 5.199e-07 0 5.19905e-07 0.9 5.202e-07 0.9 5.20205e-07 0 5.217e-07 0 5.21705e-07 0.9 5.223e-07 0.9 5.22305e-07 0 5.226e-07 0 5.22605e-07 0.9 5.229e-07 0.9 5.22905e-07 0 5.232e-07 0 5.23205e-07 0.9 5.238e-07 0.9 5.23805e-07 0 5.247e-07 0 5.24705e-07 0.9 5.25e-07 0.9 5.25005e-07 0 5.253e-07 0 5.25305e-07 0.9 5.259e-07 0.9 5.25905e-07 0 5.268e-07 0 5.26805e-07 0.9 5.271e-07 0.9 5.27105e-07 0 5.286e-07 0 5.28605e-07 0.9 5.289e-07 0.9 5.28905e-07 0 5.304e-07 0 5.30405e-07 0.9 5.307e-07 0.9 5.30705e-07 0 5.31e-07 0 5.31005e-07 0.9 5.313e-07 0.9 5.31305e-07 0 5.328e-07 0 5.32805e-07 0.9 5.331e-07 0.9 5.33105e-07 0 5.346e-07 0 5.34605e-07 0.9 5.352e-07 0.9 5.35205e-07 0 5.355e-07 0 5.35505e-07 0.9 5.358e-07 0.9 5.35805e-07 0 5.361e-07 0 5.36105e-07 0.9 5.37e-07 0.9 5.37005e-07 0 5.373e-07 0 5.37305e-07 0.9 5.376e-07 0.9 5.37605e-07 0 5.379e-07 0 5.37905e-07 0.9 5.385e-07 0.9 5.38505e-07 0 5.394e-07 0 5.39405e-07 0.9 5.397e-07 0.9 5.39705e-07 0 5.412e-07 0 5.41205e-07 0.9 5.415e-07 0.9 5.41505e-07 0 5.418e-07 0 5.41805e-07 0.9 5.421e-07 0.9 5.42105e-07 0 5.436e-07 0 5.43605e-07 0.9 5.442e-07 0.9 5.44205e-07 0 5.445e-07 0 5.44505e-07 0.9 5.448e-07 0.9 5.44805e-07 0 5.451e-07 0 5.45105e-07 0.9 5.457e-07 0.9 5.45705e-07 0 5.466e-07 0 5.46605e-07 0.9 5.469e-07 0.9 5.46905e-07 0 5.472e-07 0 5.47205e-07 0.9 5.478e-07 0.9 5.47805e-07 0 5.487e-07 0 5.48705e-07 0.9 5.49e-07 0.9 5.49005e-07 0 5.505e-07 0 5.50505e-07 0.9 5.508e-07 0.9 5.50805e-07 0 5.523e-07 0 5.52305e-07 0.9 5.526e-07 0.9 5.52605e-07 0 5.529e-07 0 5.52905e-07 0.9 5.532e-07 0.9 5.53205e-07 0 5.547e-07 0 5.54705e-07 0.9 5.55e-07 0.9 5.55005e-07 0 5.565e-07 0 5.56505e-07 0.9 5.571e-07 0.9 5.57105e-07 0 5.574e-07 0 5.57405e-07 0.9 5.577e-07 0.9 5.57705e-07 0 5.58e-07 0 5.58005e-07 0.9 5.589e-07 0.9 5.58905e-07 0 5.592e-07 0 5.59205e-07 0.9 5.595e-07 0.9 5.59505e-07 0 5.598e-07 0 5.59805e-07 0.9 5.604e-07 0.9 5.60405e-07 0 5.613e-07 0 5.61305e-07 0.9 5.616e-07 0.9 5.61605e-07 0 5.631e-07 0 5.63105e-07 0.9 5.634e-07 0.9 5.63405e-07 0 5.637e-07 0 5.63705e-07 0.9 5.64e-07 0.9 5.64005e-07 0 5.655e-07 0 5.65505e-07 0.9 5.661e-07 0.9 5.66105e-07 0 5.664e-07 0 5.66405e-07 0.9 5.667e-07 0.9 5.66705e-07 0 5.67e-07 0 5.67005e-07 0.9 5.676e-07 0.9 5.67605e-07 0 5.685e-07 0 5.68505e-07 0.9 5.688e-07 0.9 5.68805e-07 0 5.691e-07 0 5.69105e-07 0.9 5.697e-07 0.9 5.69705e-07 0 5.706e-07 0 5.70605e-07 0.9 5.709e-07 0.9 5.70905e-07 0 5.724e-07 0 5.72405e-07 0.9 5.727e-07 0.9 5.72705e-07 0 5.742e-07 0 5.74205e-07 0.9 5.745e-07 0.9 5.74505e-07 0 5.748e-07 0 5.74805e-07 0.9 5.751e-07 0.9 5.75105e-07 0 5.766e-07 0 5.76605e-07 0.9 5.769e-07 0.9 5.76905e-07 0 5.784e-07 0 5.78405e-07 0.9 5.79e-07 0.9 5.79005e-07 0 5.793e-07 0 5.79305e-07 0.9 5.796e-07 0.9 5.79605e-07 0 5.799e-07 0 5.79905e-07 0.9 5.808e-07 0.9 5.80805e-07 0 5.811e-07 0 5.81105e-07 0.9 5.814e-07 0.9 5.81405e-07 0 5.817e-07 0 5.81705e-07 0.9 5.823e-07 0.9 5.82305e-07 0 5.832e-07 0 5.83205e-07 0.9 5.835e-07 0.9 5.83505e-07 0 5.85e-07 0 5.85005e-07 0.9 5.853e-07 0.9 5.85305e-07 0 5.856e-07 0 5.85605e-07 0.9 5.859e-07 0.9 5.85905e-07 0 5.874e-07 0 5.87405e-07 0.9 5.88e-07 0.9 5.88005e-07 0 5.883e-07 0 5.88305e-07 0.9 5.886e-07 0.9 5.88605e-07 0 5.889e-07 0 5.88905e-07 0.9 5.895e-07 0.9 5.89505e-07 0 5.904e-07 0 5.90405e-07 0.9 5.907e-07 0.9 5.90705e-07 0 5.91e-07 0 5.91005e-07 0.9]
MDN2 (i2 src2 0 0) nmos_rvt l=20n nfin=1
MDP2 (i2 src2 vdd vdd) pmos_rvt l=20n nfin=2
VS3 (src3 0) vsource type=pwl wave=[0 0.9 3e-10 0.9 3.05e-10 0 6e-10 0 6.05e-10 0.9 9e-10 0.9 9.05e-10 0 1.2e-09 0 1.205e-09 0.9 1.5e-09 0.9 1.505e-09 0 2.4e-09 0 2.405e-09 0.9 2.7e-09 0.9 2.705e-09 0 3e-09 0 3.005e-09 0.9 3.3e-09 0.9 3.305e-09 0 4.2e-09 0 4.205e-09 0.9 4.5e-09 0.9 4.505e-09 0 4.8e-09 0 4.805e-09 0.9 6e-09 0.9 6.005e-09 0 6.3e-09 0 6.305e-09 0.9 7.8e-09 0.9 7.805e-09 0 8.1e-09 0 8.105e-09 0.9 9.6e-09 0.9 9.605e-09 0 9.9e-09 0 9.905e-09 0.9 1.14e-08 0.9 1.1405e-08 0 1.17e-08 0 1.1705e-08 0.9 1.29e-08 0.9 1.2905e-08 0 1.32e-08 0 1.3205e-08 0.9 1.35e-08 0.9 1.3505e-08 0 1.38e-08 0 1.3805e-08 0.9 1.41e-08 0.9 1.4105e-08 0 1.5e-08 0 1.5005e-08 0.9 1.53e-08 0.9 1.5305e-08 0 1.56e-08 0 1.5605e-08 0.9 1.68e-08 0.9 1.6805e-08 0 1.71e-08 0 1.7105e-08 0.9 1.86e-08 0.9 1.8605e-08 0 1.89e-08 0 1.8905e-08 0.9 2.01e-08 0.9 2.0105e-08 0 2.04e-08 0 2.0405e-08 0.9 2.07e-08 0.9 2.0705e-08 0 2.1e-08 0 2.1005e-08 0.9 2.22e-08 0.9 2.2205e-08 0 2.25e-08 0 2.2505e-08 0.9 2.28e-08 0.9 2.2805e-08 0 2.31e-08 0 2.3105e-08 0.9 2.34e-08 0.9 2.3405e-08 0 2.43e-08 0 2.4305e-08 0.9 2.46e-08 0.9 2.4605e-08 0 2.49e-08 0 2.4905e-08 0.9 2.52e-08 0.9 2.5205e-08 0 2.61e-08 0 2.6105e-08 0.9 2.64e-08 0.9 2.6405e-08 0 2.67e-08 0 2.6705e-08 0.9 2.79e-08 0.9 2.7905e-08 0 2.82e-08 0 2.8205e-08 0.9 2.97e-08 0.9 2.9705e-08 0 3e-08 0 3.0005e-08 0.9 3.15e-08 0.9 3.1505e-08 0 3.18e-08 0 3.1805e-08 0.9 3.33e-08 0.9 3.3305e-08 0 3.36e-08 0 3.3605e-08 0.9 3.48e-08 0.9 3.4805e-08 0 3.51e-08 0 3.5105e-08 0.9 3.54e-08 0.9 3.5405e-08 0 3.57e-08 0 3.5705e-08 0.9 3.6e-08 0.9 3.6005e-08 0 3.69e-08 0 3.6905e-08 0.9 3.72e-08 0.9 3.7205e-08 0 3.75e-08 0 3.7505e-08 0.9 3.87e-08 0.9 3.8705e-08 0 3.9e-08 0 3.9005e-08 0.9 4.05e-08 0.9 4.0505e-08 0 4.08e-08 0 4.0805e-08 0.9 4.2e-08 0.9 4.2005e-08 0 4.23e-08 0 4.2305e-08 0.9 4.26e-08 0.9 4.2605e-08 0 4.29e-08 0 4.2905e-08 0.9 4.41e-08 0.9 4.4105e-08 0 4.44e-08 0 4.4405e-08 0.9 4.47e-08 0.9 4.4705e-08 0 4.5e-08 0 4.5005e-08 0.9 4.53e-08 0.9 4.5305e-08 0 4.62e-08 0 4.6205e-08 0.9 4.65e-08 0.9 4.6505e-08 0 4.68e-08 0 4.6805e-08 0.9 4.71e-08 0.9 4.7105e-08 0 4.8e-08 0 4.8005e-08 0.9 4.83e-08 0.9 4.8305e-08 0 4.86e-08 0 4.8605e-08 0.9 4.98e-08 0.9 4.9805e-08 0 5.01e-08 0 5.0105e-08 0.9 5.16e-08 0.9 5.1605e-08 0 5.19e-08 0 5.1905e-08 0.9 5.34e-08 0.9 5.3405e-08 0 5.37e-08 0 5.3705e-08 0.9 5.52e-08 0.9 5.5205e-08 0 5.55e-08 0 5.5505e-08 0.9 5.67e-08 0.9 5.6705e-08 0 5.7e-08 0 5.7005e-08 0.9 5.73e-08 0.9 5.7305e-08 0 5.76e-08 0 5.7605e-08 0.9 5.79e-08 0.9 5.7905e-08 0 5.88e-08 0 5.8805e-08 0.9 5.91e-08 0.9 5.9105e-08 0 5.94e-08 0 5.9405e-08 0.9 6.06e-08 0.9 6.0605e-08 0 6.09e-08 0 6.0905e-08 0.9 6.24e-08 0.9 6.2405e-08 0 6.27e-08 0 6.2705e-08 0.9 6.39e-08 0.9 6.3905e-08 0 6.42e-08 0 6.4205e-08 0.9 6.45e-08 0.9 6.4505e-08 0 6.48e-08 0 6.4805e-08 0.9 6.6e-08 0.9 6.6005e-08 0 6.63e-08 0 6.6305e-08 0.9 6.66e-08 0.9 6.6605e-08 0 6.69e-08 0 6.6905e-08 0.9 6.72e-08 0.9 6.7205e-08 0 6.81e-08 0 6.8105e-08 0.9 6.84e-08 0.9 6.8405e-08 0 6.87e-08 0 6.8705e-08 0.9 6.9e-08 0.9 6.9005e-08 0 6.99e-08 0 6.9905e-08 0.9 7.02e-08 0.9 7.0205e-08 0 7.05e-08 0 7.0505e-08 0.9 7.17e-08 0.9 7.1705e-08 0 7.2e-08 0 7.2005e-08 0.9 7.35e-08 0.9 7.3505e-08 0 7.38e-08 0 7.3805e-08 0.9 7.53e-08 0.9 7.5305e-08 0 7.56e-08 0 7.5605e-08 0.9 7.71e-08 0.9 7.7105e-08 0 7.74e-08 0 7.7405e-08 0.9 7.86e-08 0.9 7.8605e-08 0 7.89e-08 0 7.8905e-08 0.9 7.92e-08 0.9 7.9205e-08 0 7.95e-08 0 7.9505e-08 0.9 7.98e-08 0.9 7.9805e-08 0 8.07e-08 0 8.0705e-08 0.9 8.1e-08 0.9 8.1005e-08 0 8.13e-08 0 8.1305e-08 0.9 8.25e-08 0.9 8.2505e-08 0 8.28e-08 0 8.2805e-08 0.9 8.43e-08 0.9 8.4305e-08 0 8.46e-08 0 8.4605e-08 0.9 8.58e-08 0.9 8.5805e-08 0 8.61e-08 0 8.6105e-08 0.9 8.64e-08 0.9 8.6405e-08 0 8.67e-08 0 8.6705e-08 0.9 8.79e-08 0.9 8.7905e-08 0 8.82e-08 0 8.8205e-08 0.9 8.85e-08 0.9 8.8505e-08 0 8.88e-08 0 8.8805e-08 0.9 8.91e-08 0.9 8.9105e-08 0 9e-08 0 9.0005e-08 0.9 9.03e-08 0.9 9.0305e-08 0 9.06e-08 0 9.0605e-08 0.9 9.09e-08 0.9 9.0905e-08 0 9.18e-08 0 9.1805e-08 0.9 9.21e-08 0.9 9.2105e-08 0 9.24e-08 0 9.2405e-08 0.9 9.36e-08 0.9 9.3605e-08 0 9.39e-08 0 9.3905e-08 0.9 9.54e-08 0.9 9.5405e-08 0 9.57e-08 0 9.5705e-08 0.9 9.72e-08 0.9 9.7205e-08 0 9.75e-08 0 9.7505e-08 0.9 9.9e-08 0.9 9.9005e-08 0 9.93e-08 0 9.9305e-08 0.9 1.005e-07 0.9 1.00505e-07 0 1.008e-07 0 1.00805e-07 0.9 1.011e-07 0.9 1.01105e-07 0 1.014e-07 0 1.01405e-07 0.9 1.017e-07 0.9 1.01705e-07 0 1.026e-07 0 1.02605e-07 0.9 1.029e-07 0.9 1.02905e-07 0 1.032e-07 0 1.03205e-07 0.9 1.044e-07 0.9 1.04405e-07 0 1.047e-07 0 1.04705e-07 0.9 1.062e-07 0.9 1.06205e-07 0 1.065e-07 0 1.06505e-07 0.9 1.077e-07 0.9 1.07705e-07 0 1.08e-07 0 1.08005e-07 0.9 1.083e-07 0.9 1.08305e-07 0 1.086e-07 0 1.08605e-07 0.9 1.098e-07 0.9 1.09805e-07 0 1.101e-07 0 1.10105e-07 0.9 1.104e-07 0.9 1.10405e-07 0 1.107e-07 0 1.10705e-07 0.9 1.11e-07 0.9 1.11005e-07 0 1.119e-07 0 1.11905e-07 0.9 1.122e-07 0.9 1.12205e-07 0 1.125e-07 0 1.12505e-07 0.9 1.128e-07 0.9 1.12805e-07 0 1.137e-07 0 1.13705e-07 0.9 1.14e-07 0.9 1.14005e-07 0 1.143e-07 0 1.14305e-07 0.9 1.155e-07 0.9 1.15505e-07 0 1.158e-07 0 1.15805e-07 0.9 1.173e-07 0.9 1.17305e-07 0 1.176e-07 0 1.17605e-07 0.9 1.191e-07 0.9 1.19105e-07 0 1.194e-07 0 1.19405e-07 0.9 1.209e-07 0.9 1.20905e-07 0 1.212e-07 0 1.21205e-07 0.9 1.224e-07 0.9 1.22405e-07 0 1.227e-07 0 1.22705e-07 0.9 1.23e-07 0.9 1.23005e-07 0 1.233e-07 0 1.23305e-07 0.9 1.236e-07 0.9 1.23605e-07 0 1.245e-07 0 1.24505e-07 0.9 1.248e-07 0.9 1.24805e-07 0 1.251e-07 0 1.25105e-07 0.9 1.263e-07 0.9 1.26305e-07 0 1.266e-07 0 1.26605e-07 0.9 1.281e-07 0.9 1.28105e-07 0 1.284e-07 0 1.28405e-07 0.9 1.296e-07 0.9 1.29605e-07 0 1.299e-07 0 1.29905e-07 0.9 1.302e-07 0.9 1.30205e-07 0 1.305e-07 0 1.30505e-07 0.9 1.317e-07 0.9 1.31705e-07 0 1.32e-07 0 1.32005e-07 0.9 1.323e-07 0.9 1.32305e-07 0 1.326e-07 0 1.32605e-07 0.9 1.329e-07 0.9 1.32905e-07 0 1.338e-07 0 1.33805e-07 0.9 1.341e-07 0.9 1.34105e-07 0 1.344e-07 0 1.34405e-07 0.9 1.347e-07 0.9 1.34705e-07 0 1.356e-07 0 1.35605e-07 0.9 1.359e-07 0.9 1.35905e-07 0 1.362e-07 0 1.36205e-07 0.9 1.374e-07 0.9 1.37405e-07 0 1.377e-07 0 1.37705e-07 0.9 1.392e-07 0.9 1.39205e-07 0 1.395e-07 0 1.39505e-07 0.9 1.41e-07 0.9 1.41005e-07 0 1.413e-07 0 1.41305e-07 0.9 1.428e-07 0.9 1.42805e-07 0 1.431e-07 0 1.43105e-07 0.9 1.443e-07 0.9 1.44305e-07 0 1.446e-07 0 1.44605e-07 0.9 1.449e-07 0.9 1.44905e-07 0 1.452e-07 0 1.45205e-07 0.9 1.455e-07 0.9 1.45505e-07 0 1.464e-07 0 1.46405e-07 0.9 1.467e-07 0.9 1.46705e-07 0 1.47e-07 0 1.47005e-07 0.9 1.482e-07 0.9 1.48205e-07 0 1.485e-07 0 1.48505e-07 0.9 1.5e-07 0.9 1.50005e-07 0 1.503e-07 0 1.50305e-07 0.9 1.515e-07 0.9 1.51505e-07 0 1.518e-07 0 1.51805e-07 0.9 1.521e-07 0.9 1.52105e-07 0 1.524e-07 0 1.52405e-07 0.9 1.536e-07 0.9 1.53605e-07 0 1.539e-07 0 1.53905e-07 0.9 1.542e-07 0.9 1.54205e-07 0 1.545e-07 0 1.54505e-07 0.9 1.548e-07 0.9 1.54805e-07 0 1.557e-07 0 1.55705e-07 0.9 1.56e-07 0.9 1.56005e-07 0 1.563e-07 0 1.56305e-07 0.9 1.566e-07 0.9 1.56605e-07 0 1.575e-07 0 1.57505e-07 0.9 1.578e-07 0.9 1.57805e-07 0 1.581e-07 0 1.58105e-07 0.9 1.593e-07 0.9 1.59305e-07 0 1.596e-07 0 1.59605e-07 0.9 1.611e-07 0.9 1.61105e-07 0 1.614e-07 0 1.61405e-07 0.9 1.629e-07 0.9 1.62905e-07 0 1.632e-07 0 1.63205e-07 0.9 1.647e-07 0.9 1.64705e-07 0 1.65e-07 0 1.65005e-07 0.9 1.662e-07 0.9 1.66205e-07 0 1.665e-07 0 1.66505e-07 0.9 1.668e-07 0.9 1.66805e-07 0 1.671e-07 0 1.67105e-07 0.9 1.674e-07 0.9 1.67405e-07 0 1.683e-07 0 1.68305e-07 0.9 1.686e-07 0.9 1.68605e-07 0 1.689e-07 0 1.68905e-07 0.9 1.701e-07 0.9 1.70105e-07 0 1.704e-07 0 1.70405e-07 0.9 1.719e-07 0.9 1.71905e-07 0 1.722e-07 0 1.72205e-07 0.9 1.734e-07 0.9 1.73405e-07 0 1.737e-07 0 1.73705e-07 0.9 1.74e-07 0.9 1.74005e-07 0 1.743e-07 0 1.74305e-07 0.9 1.755e-07 0.9 1.75505e-07 0 1.758e-07 0 1.75805e-07 0.9 1.761e-07 0.9 1.76105e-07 0 1.764e-07 0 1.76405e-07 0.9 1.767e-07 0.9 1.76705e-07 0 1.776e-07 0 1.77605e-07 0.9 1.779e-07 0.9 1.77905e-07 0 1.782e-07 0 1.78205e-07 0.9 1.785e-07 0.9 1.78505e-07 0 1.794e-07 0 1.79405e-07 0.9 1.797e-07 0.9 1.79705e-07 0 1.8e-07 0 1.80005e-07 0.9 1.812e-07 0.9 1.81205e-07 0 1.815e-07 0 1.81505e-07 0.9 1.83e-07 0.9 1.83005e-07 0 1.833e-07 0 1.83305e-07 0.9 1.848e-07 0.9 1.84805e-07 0 1.851e-07 0 1.85105e-07 0.9 1.866e-07 0.9 1.86605e-07 0 1.869e-07 0 1.86905e-07 0.9 1.881e-07 0.9 1.88105e-07 0 1.884e-07 0 1.88405e-07 0.9 1.887e-07 0.9 1.88705e-07 0 1.89e-07 0 1.89005e-07 0.9 1.893e-07 0.9 1.89305e-07 0 1.902e-07 0 1.90205e-07 0.9 1.905e-07 0.9 1.90505e-07 0 1.908e-07 0 1.90805e-07 0.9 1.92e-07 0.9 1.92005e-07 0 1.923e-07 0 1.92305e-07 0.9 1.938e-07 0.9 1.93805e-07 0 1.941e-07 0 1.94105e-07 0.9 1.953e-07 0.9 1.95305e-07 0 1.956e-07 0 1.95605e-07 0.9 1.959e-07 0.9 1.95905e-07 0 1.962e-07 0 1.96205e-07 0.9 1.974e-07 0.9 1.97405e-07 0 1.977e-07 0 1.97705e-07 0.9 1.98e-07 0.9 1.98005e-07 0 1.983e-07 0 1.98305e-07 0.9 1.986e-07 0.9 1.98605e-07 0 1.995e-07 0 1.99505e-07 0.9 1.998e-07 0.9 1.99805e-07 0 2.001e-07 0 2.00105e-07 0.9 2.004e-07 0.9 2.00405e-07 0 2.013e-07 0 2.01305e-07 0.9 2.016e-07 0.9 2.01605e-07 0 2.019e-07 0 2.01905e-07 0.9 2.031e-07 0.9 2.03105e-07 0 2.034e-07 0 2.03405e-07 0.9 2.049e-07 0.9 2.04905e-07 0 2.052e-07 0 2.05205e-07 0.9 2.067e-07 0.9 2.06705e-07 0 2.07e-07 0 2.07005e-07 0.9 2.085e-07 0.9 2.08505e-07 0 2.088e-07 0 2.08805e-07 0.9 2.1e-07 0.9 2.10005e-07 0 2.103e-07 0 2.10305e-07 0.9 2.106e-07 0.9 2.10605e-07 0 2.109e-07 0 2.10905e-07 0.9 2.112e-07 0.9 2.11205e-07 0 2.121e-07 0 2.12105e-07 0.9 2.124e-07 0.9 2.12405e-07 0 2.127e-07 0 2.12705e-07 0.9 2.139e-07 0.9 2.13905e-07 0 2.142e-07 0 2.14205e-07 0.9 2.157e-07 0.9 2.15705e-07 0 2.16e-07 0 2.16005e-07 0.9 2.172e-07 0.9 2.17205e-07 0 2.175e-07 0 2.17505e-07 0.9 2.178e-07 0.9 2.17805e-07 0 2.181e-07 0 2.18105e-07 0.9 2.193e-07 0.9 2.19305e-07 0 2.196e-07 0 2.19605e-07 0.9 2.199e-07 0.9 2.19905e-07 0 2.202e-07 0 2.20205e-07 0.9 2.205e-07 0.9 2.20505e-07 0 2.214e-07 0 2.21405e-07 0.9 2.217e-07 0.9 2.21705e-07 0 2.22e-07 0 2.22005e-07 0.9 2.223e-07 0.9 2.22305e-07 0 2.232e-07 0 2.23205e-07 0.9 2.235e-07 0.9 2.23505e-07 0 2.238e-07 0 2.23805e-07 0.9 2.25e-07 0.9 2.25005e-07 0 2.253e-07 0 2.25305e-07 0.9 2.268e-07 0.9 2.26805e-07 0 2.271e-07 0 2.27105e-07 0.9 2.286e-07 0.9 2.28605e-07 0 2.289e-07 0 2.28905e-07 0.9 2.304e-07 0.9 2.30405e-07 0 2.307e-07 0 2.30705e-07 0.9 2.319e-07 0.9 2.31905e-07 0 2.322e-07 0 2.32205e-07 0.9 2.325e-07 0.9 2.32505e-07 0 2.328e-07 0 2.32805e-07 0.9 2.331e-07 0.9 2.33105e-07 0 2.34e-07 0 2.34005e-07 0.9 2.343e-07 0.9 2.34305e-07 0 2.346e-07 0 2.34605e-07 0.9 2.358e-07 0.9 2.35805e-07 0 2.361e-07 0 2.36105e-07 0.9 2.376e-07 0.9 2.37605e-07 0 2.379e-07 0 2.37905e-07 0.9 2.391e-07 0.9 2.39105e-07 0 2.394e-07 0 2.39405e-07 0.9 2.397e-07 0.9 2.39705e-07 0 2.4e-07 0 2.40005e-07 0.9 2.412e-07 0.9 2.41205e-07 0 2.415e-07 0 2.41505e-07 0.9 2.418e-07 0.9 2.41805e-07 0 2.421e-07 0 2.42105e-07 0.9 2.424e-07 0.9 2.42405e-07 0 2.433e-07 0 2.43305e-07 0.9 2.436e-07 0.9 2.43605e-07 0 2.439e-07 0 2.43905e-07 0.9 2.442e-07 0.9 2.44205e-07 0 2.451e-07 0 2.45105e-07 0.9 2.454e-07 0.9 2.45405e-07 0 2.457e-07 0 2.45705e-07 0.9 2.469e-07 0.9 2.46905e-07 0 2.472e-07 0 2.47205e-07 0.9 2.487e-07 0.9 2.48705e-07 0 2.49e-07 0 2.49005e-07 0.9 2.505e-07 0.9 2.50505e-07 0 2.508e-07 0 2.50805e-07 0.9 2.523e-07 0.9 2.52305e-07 0 2.526e-07 0 2.52605e-07 0.9 2.538e-07 0.9 2.53805e-07 0 2.541e-07 0 2.54105e-07 0.9 2.544e-07 0.9 2.54405e-07 0 2.547e-07 0 2.54705e-07 0.9 2.55e-07 0.9 2.55005e-07 0 2.559e-07 0 2.55905e-07 0.9 2.562e-07 0.9 2.56205e-07 0 2.565e-07 0 2.56505e-07 0.9 2.577e-07 0.9 2.57705e-07 0 2.58e-07 0 2.58005e-07 0.9 2.595e-07 0.9 2.59505e-07 0 2.598e-07 0 2.59805e-07 0.9 2.61e-07 0.9 2.61005e-07 0 2.613e-07 0 2.61305e-07 0.9 2.616e-07 0.9 2.61605e-07 0 2.619e-07 0 2.61905e-07 0.9 2.631e-07 0.9 2.63105e-07 0 2.634e-07 0 2.63405e-07 0.9 2.637e-07 0.9 2.63705e-07 0 2.64e-07 0 2.64005e-07 0.9 2.643e-07 0.9 2.64305e-07 0 2.652e-07 0 2.65205e-07 0.9 2.655e-07 0.9 2.65505e-07 0 2.658e-07 0 2.65805e-07 0.9 2.661e-07 0.9 2.66105e-07 0 2.67e-07 0 2.67005e-07 0.9 2.673e-07 0.9 2.67305e-07 0 2.676e-07 0 2.67605e-07 0.9 2.688e-07 0.9 2.68805e-07 0 2.691e-07 0 2.69105e-07 0.9 2.706e-07 0.9 2.70605e-07 0 2.709e-07 0 2.70905e-07 0.9 2.724e-07 0.9 2.72405e-07 0 2.727e-07 0 2.72705e-07 0.9 2.742e-07 0.9 2.74205e-07 0 2.745e-07 0 2.74505e-07 0.9 2.757e-07 0.9 2.75705e-07 0 2.76e-07 0 2.76005e-07 0.9 2.763e-07 0.9 2.76305e-07 0 2.766e-07 0 2.76605e-07 0.9 2.769e-07 0.9 2.76905e-07 0 2.778e-07 0 2.77805e-07 0.9 2.781e-07 0.9 2.78105e-07 0 2.784e-07 0 2.78405e-07 0.9 2.796e-07 0.9 2.79605e-07 0 2.799e-07 0 2.79905e-07 0.9 2.814e-07 0.9 2.81405e-07 0 2.817e-07 0 2.81705e-07 0.9 2.829e-07 0.9 2.82905e-07 0 2.832e-07 0 2.83205e-07 0.9 2.835e-07 0.9 2.83505e-07 0 2.838e-07 0 2.83805e-07 0.9 2.85e-07 0.9 2.85005e-07 0 2.853e-07 0 2.85305e-07 0.9 2.856e-07 0.9 2.85605e-07 0 2.859e-07 0 2.85905e-07 0.9 2.862e-07 0.9 2.86205e-07 0 2.871e-07 0 2.87105e-07 0.9 2.874e-07 0.9 2.87405e-07 0 2.877e-07 0 2.87705e-07 0.9 2.88e-07 0.9 2.88005e-07 0 2.889e-07 0 2.88905e-07 0.9 2.892e-07 0.9 2.89205e-07 0 2.895e-07 0 2.89505e-07 0.9 2.907e-07 0.9 2.90705e-07 0 2.91e-07 0 2.91005e-07 0.9 2.925e-07 0.9 2.92505e-07 0 2.928e-07 0 2.92805e-07 0.9 2.943e-07 0.9 2.94305e-07 0 2.946e-07 0 2.94605e-07 0.9 2.961e-07 0.9 2.96105e-07 0 2.964e-07 0 2.96405e-07 0.9 2.976e-07 0.9 2.97605e-07 0 2.979e-07 0 2.97905e-07 0.9 2.982e-07 0.9 2.98205e-07 0 2.985e-07 0 2.98505e-07 0.9 2.988e-07 0.9 2.98805e-07 0 2.997e-07 0 2.99705e-07 0.9 3e-07 0.9 3.00005e-07 0 3.003e-07 0 3.00305e-07 0.9 3.015e-07 0.9 3.01505e-07 0 3.018e-07 0 3.01805e-07 0.9 3.033e-07 0.9 3.03305e-07 0 3.036e-07 0 3.03605e-07 0.9 3.048e-07 0.9 3.04805e-07 0 3.051e-07 0 3.05105e-07 0.9 3.054e-07 0.9 3.05405e-07 0 3.057e-07 0 3.05705e-07 0.9 3.069e-07 0.9 3.06905e-07 0 3.072e-07 0 3.07205e-07 0.9 3.075e-07 0.9 3.07505e-07 0 3.078e-07 0 3.07805e-07 0.9 3.081e-07 0.9 3.08105e-07 0 3.09e-07 0 3.09005e-07 0.9 3.093e-07 0.9 3.09305e-07 0 3.096e-07 0 3.09605e-07 0.9 3.099e-07 0.9 3.09905e-07 0 3.108e-07 0 3.10805e-07 0.9 3.111e-07 0.9 3.11105e-07 0 3.114e-07 0 3.11405e-07 0.9 3.126e-07 0.9 3.12605e-07 0 3.129e-07 0 3.12905e-07 0.9 3.144e-07 0.9 3.14405e-07 0 3.147e-07 0 3.14705e-07 0.9 3.162e-07 0.9 3.16205e-07 0 3.165e-07 0 3.16505e-07 0.9 3.18e-07 0.9 3.18005e-07 0 3.183e-07 0 3.18305e-07 0.9 3.195e-07 0.9 3.19505e-07 0 3.198e-07 0 3.19805e-07 0.9 3.201e-07 0.9 3.20105e-07 0 3.204e-07 0 3.20405e-07 0.9 3.207e-07 0.9 3.20705e-07 0 3.216e-07 0 3.21605e-07 0.9 3.219e-07 0.9 3.21905e-07 0 3.222e-07 0 3.22205e-07 0.9 3.234e-07 0.9 3.23405e-07 0 3.237e-07 0 3.23705e-07 0.9 3.252e-07 0.9 3.25205e-07 0 3.255e-07 0 3.25505e-07 0.9 3.267e-07 0.9 3.26705e-07 0 3.27e-07 0 3.27005e-07 0.9 3.273e-07 0.9 3.27305e-07 0 3.276e-07 0 3.27605e-07 0.9 3.288e-07 0.9 3.28805e-07 0 3.291e-07 0 3.29105e-07 0.9 3.294e-07 0.9 3.29405e-07 0 3.297e-07 0 3.29705e-07 0.9 3.3e-07 0.9 3.30005e-07 0 3.309e-07 0 3.30905e-07 0.9 3.312e-07 0.9 3.31205e-07 0 3.315e-07 0 3.31505e-07 0.9 3.318e-07 0.9 3.31805e-07 0 3.327e-07 0 3.32705e-07 0.9 3.33e-07 0.9 3.33005e-07 0 3.333e-07 0 3.33305e-07 0.9 3.345e-07 0.9 3.34505e-07 0 3.348e-07 0 3.34805e-07 0.9 3.363e-07 0.9 3.36305e-07 0 3.366e-07 0 3.36605e-07 0.9 3.381e-07 0.9 3.38105e-07 0 3.384e-07 0 3.38405e-07 0.9 3.399e-07 0.9 3.39905e-07 0 3.402e-07 0 3.40205e-07 0.9 3.414e-07 0.9 3.41405e-07 0 3.417e-07 0 3.41705e-07 0.9 3.42e-07 0.9 3.42005e-07 0 3.423e-07 0 3.42305e-07 0.9 3.426e-07 0.9 3.42605e-07 0 3.435e-07 0 3.43505e-07 0.9 3.438e-07 0.9 3.43805e-07 0 3.441e-07 0 3.44105e-07 0.9 3.453e-07 0.9 3.45305e-07 0 3.456e-07 0 3.45605e-07 0.9 3.471e-07 0.9 3.47105e-07 0 3.474e-07 0 3.47405e-07 0.9 3.486e-07 0.9 3.48605e-07 0 3.489e-07 0 3.48905e-07 0.9 3.492e-07 0.9 3.49205e-07 0 3.495e-07 0 3.49505e-07 0.9 3.507e-07 0.9 3.50705e-07 0 3.51e-07 0 3.51005e-07 0.9 3.513e-07 0.9 3.51305e-07 0 3.516e-07 0 3.51605e-07 0.9 3.519e-07 0.9 3.51905e-07 0 3.528e-07 0 3.52805e-07 0.9 3.531e-07 0.9 3.53105e-07 0 3.534e-07 0 3.53405e-07 0.9 3.537e-07 0.9 3.53705e-07 0 3.546e-07 0 3.54605e-07 0.9 3.549e-07 0.9 3.54905e-07 0 3.552e-07 0 3.55205e-07 0.9 3.564e-07 0.9 3.56405e-07 0 3.567e-07 0 3.56705e-07 0.9 3.582e-07 0.9 3.58205e-07 0 3.585e-07 0 3.58505e-07 0.9 3.6e-07 0.9 3.60005e-07 0 3.603e-07 0 3.60305e-07 0.9 3.618e-07 0.9 3.61805e-07 0 3.621e-07 0 3.62105e-07 0.9 3.633e-07 0.9 3.63305e-07 0 3.636e-07 0 3.63605e-07 0.9 3.639e-07 0.9 3.63905e-07 0 3.642e-07 0 3.64205e-07 0.9 3.645e-07 0.9 3.64505e-07 0 3.654e-07 0 3.65405e-07 0.9 3.657e-07 0.9 3.65705e-07 0 3.66e-07 0 3.66005e-07 0.9 3.672e-07 0.9 3.67205e-07 0 3.675e-07 0 3.67505e-07 0.9 3.69e-07 0.9 3.69005e-07 0 3.693e-07 0 3.69305e-07 0.9 3.705e-07 0.9 3.70505e-07 0 3.708e-07 0 3.70805e-07 0.9 3.711e-07 0.9 3.71105e-07 0 3.714e-07 0 3.71405e-07 0.9 3.726e-07 0.9 3.72605e-07 0 3.729e-07 0 3.72905e-07 0.9 3.732e-07 0.9 3.73205e-07 0 3.735e-07 0 3.73505e-07 0.9 3.738e-07 0.9 3.73805e-07 0 3.747e-07 0 3.74705e-07 0.9 3.75e-07 0.9 3.75005e-07 0 3.753e-07 0 3.75305e-07 0.9 3.756e-07 0.9 3.75605e-07 0 3.765e-07 0 3.76505e-07 0.9 3.768e-07 0.9 3.76805e-07 0 3.771e-07 0 3.77105e-07 0.9 3.783e-07 0.9 3.78305e-07 0 3.786e-07 0 3.78605e-07 0.9 3.801e-07 0.9 3.80105e-07 0 3.804e-07 0 3.80405e-07 0.9 3.819e-07 0.9 3.81905e-07 0 3.822e-07 0 3.82205e-07 0.9 3.837e-07 0.9 3.83705e-07 0 3.84e-07 0 3.84005e-07 0.9 3.852e-07 0.9 3.85205e-07 0 3.855e-07 0 3.85505e-07 0.9 3.858e-07 0.9 3.85805e-07 0 3.861e-07 0 3.86105e-07 0.9 3.864e-07 0.9 3.86405e-07 0 3.873e-07 0 3.87305e-07 0.9 3.876e-07 0.9 3.87605e-07 0 3.879e-07 0 3.87905e-07 0.9 3.891e-07 0.9 3.89105e-07 0 3.894e-07 0 3.89405e-07 0.9 3.909e-07 0.9 3.90905e-07 0 3.912e-07 0 3.91205e-07 0.9 3.924e-07 0.9 3.92405e-07 0 3.927e-07 0 3.92705e-07 0.9 3.93e-07 0.9 3.93005e-07 0 3.933e-07 0 3.93305e-07 0.9 3.945e-07 0.9 3.94505e-07 0 3.948e-07 0 3.94805e-07 0.9 3.951e-07 0.9 3.95105e-07 0 3.954e-07 0 3.95405e-07 0.9 3.957e-07 0.9 3.95705e-07 0 3.966e-07 0 3.96605e-07 0.9 3.969e-07 0.9 3.96905e-07 0 3.972e-07 0 3.97205e-07 0.9 3.975e-07 0.9 3.97505e-07 0 3.984e-07 0 3.98405e-07 0.9 3.987e-07 0.9 3.98705e-07 0 3.99e-07 0 3.99005e-07 0.9 4.002e-07 0.9 4.00205e-07 0 4.005e-07 0 4.00505e-07 0.9 4.02e-07 0.9 4.02005e-07 0 4.023e-07 0 4.02305e-07 0.9 4.038e-07 0.9 4.03805e-07 0 4.041e-07 0 4.04105e-07 0.9 4.056e-07 0.9 4.05605e-07 0 4.059e-07 0 4.05905e-07 0.9 4.071e-07 0.9 4.07105e-07 0 4.074e-07 0 4.07405e-07 0.9 4.077e-07 0.9 4.07705e-07 0 4.08e-07 0 4.08005e-07 0.9 4.083e-07 0.9 4.08305e-07 0 4.092e-07 0 4.09205e-07 0.9 4.095e-07 0.9 4.09505e-07 0 4.098e-07 0 4.09805e-07 0.9 4.11e-07 0.9 4.11005e-07 0 4.113e-07 0 4.11305e-07 0.9 4.128e-07 0.9 4.12805e-07 0 4.131e-07 0 4.13105e-07 0.9 4.143e-07 0.9 4.14305e-07 0 4.146e-07 0 4.14605e-07 0.9 4.149e-07 0.9 4.14905e-07 0 4.152e-07 0 4.15205e-07 0.9 4.164e-07 0.9 4.16405e-07 0 4.167e-07 0 4.16705e-07 0.9 4.17e-07 0.9 4.17005e-07 0 4.173e-07 0 4.17305e-07 0.9 4.176e-07 0.9 4.17605e-07 0 4.185e-07 0 4.18505e-07 0.9 4.188e-07 0.9 4.18805e-07 0 4.191e-07 0 4.19105e-07 0.9 4.194e-07 0.9 4.19405e-07 0 4.203e-07 0 4.20305e-07 0.9 4.206e-07 0.9 4.20605e-07 0 4.209e-07 0 4.20905e-07 0.9 4.221e-07 0.9 4.22105e-07 0 4.224e-07 0 4.22405e-07 0.9 4.239e-07 0.9 4.23905e-07 0 4.242e-07 0 4.24205e-07 0.9 4.257e-07 0.9 4.25705e-07 0 4.26e-07 0 4.26005e-07 0.9 4.275e-07 0.9 4.27505e-07 0 4.278e-07 0 4.27805e-07 0.9 4.29e-07 0.9 4.29005e-07 0 4.293e-07 0 4.29305e-07 0.9 4.296e-07 0.9 4.29605e-07 0 4.299e-07 0 4.29905e-07 0.9 4.302e-07 0.9 4.30205e-07 0 4.311e-07 0 4.31105e-07 0.9 4.314e-07 0.9 4.31405e-07 0 4.317e-07 0 4.31705e-07 0.9 4.329e-07 0.9 4.32905e-07 0 4.332e-07 0 4.33205e-07 0.9 4.347e-07 0.9 4.34705e-07 0 4.35e-07 0 4.35005e-07 0.9 4.362e-07 0.9 4.36205e-07 0 4.365e-07 0 4.36505e-07 0.9 4.368e-07 0.9 4.36805e-07 0 4.371e-07 0 4.37105e-07 0.9 4.383e-07 0.9 4.38305e-07 0 4.386e-07 0 4.38605e-07 0.9 4.389e-07 0.9 4.38905e-07 0 4.392e-07 0 4.39205e-07 0.9 4.395e-07 0.9 4.39505e-07 0 4.404e-07 0 4.40405e-07 0.9 4.407e-07 0.9 4.40705e-07 0 4.41e-07 0 4.41005e-07 0.9 4.413e-07 0.9 4.41305e-07 0 4.422e-07 0 4.42205e-07 0.9 4.425e-07 0.9 4.42505e-07 0 4.428e-07 0 4.42805e-07 0.9 4.44e-07 0.9 4.44005e-07 0 4.443e-07 0 4.44305e-07 0.9 4.458e-07 0.9 4.45805e-07 0 4.461e-07 0 4.46105e-07 0.9 4.476e-07 0.9 4.47605e-07 0 4.479e-07 0 4.47905e-07 0.9 4.494e-07 0.9 4.49405e-07 0 4.497e-07 0 4.49705e-07 0.9 4.509e-07 0.9 4.50905e-07 0 4.512e-07 0 4.51205e-07 0.9 4.515e-07 0.9 4.51505e-07 0 4.518e-07 0 4.51805e-07 0.9 4.521e-07 0.9 4.52105e-07 0 4.53e-07 0 4.53005e-07 0.9 4.533e-07 0.9 4.53305e-07 0 4.536e-07 0 4.53605e-07 0.9 4.548e-07 0.9 4.54805e-07 0 4.551e-07 0 4.55105e-07 0.9 4.566e-07 0.9 4.56605e-07 0 4.569e-07 0 4.56905e-07 0.9 4.581e-07 0.9 4.58105e-07 0 4.584e-07 0 4.58405e-07 0.9 4.587e-07 0.9 4.58705e-07 0 4.59e-07 0 4.59005e-07 0.9 4.602e-07 0.9 4.60205e-07 0 4.605e-07 0 4.60505e-07 0.9 4.608e-07 0.9 4.60805e-07 0 4.611e-07 0 4.61105e-07 0.9 4.614e-07 0.9 4.61405e-07 0 4.623e-07 0 4.62305e-07 0.9 4.626e-07 0.9 4.62605e-07 0 4.629e-07 0 4.62905e-07 0.9 4.632e-07 0.9 4.63205e-07 0 4.641e-07 0 4.64105e-07 0.9 4.644e-07 0.9 4.64405e-07 0 4.647e-07 0 4.64705e-07 0.9 4.659e-07 0.9 4.65905e-07 0 4.662e-07 0 4.66205e-07 0.9 4.677e-07 0.9 4.67705e-07 0 4.68e-07 0 4.68005e-07 0.9 4.695e-07 0.9 4.69505e-07 0 4.698e-07 0 4.69805e-07 0.9 4.713e-07 0.9 4.71305e-07 0 4.716e-07 0 4.71605e-07 0.9 4.728e-07 0.9 4.72805e-07 0 4.731e-07 0 4.73105e-07 0.9 4.734e-07 0.9 4.73405e-07 0 4.737e-07 0 4.73705e-07 0.9 4.74e-07 0.9 4.74005e-07 0 4.749e-07 0 4.74905e-07 0.9 4.752e-07 0.9 4.75205e-07 0 4.755e-07 0 4.75505e-07 0.9 4.767e-07 0.9 4.76705e-07 0 4.77e-07 0 4.77005e-07 0.9 4.785e-07 0.9 4.78505e-07 0 4.788e-07 0 4.78805e-07 0.9 4.8e-07 0.9 4.80005e-07 0 4.803e-07 0 4.80305e-07 0.9 4.806e-07 0.9 4.80605e-07 0 4.809e-07 0 4.80905e-07 0.9 4.821e-07 0.9 4.82105e-07 0 4.824e-07 0 4.82405e-07 0.9 4.827e-07 0.9 4.82705e-07 0 4.83e-07 0 4.83005e-07 0.9 4.833e-07 0.9 4.83305e-07 0 4.842e-07 0 4.84205e-07 0.9 4.845e-07 0.9 4.84505e-07 0 4.848e-07 0 4.84805e-07 0.9 4.851e-07 0.9 4.85105e-07 0 4.86e-07 0 4.86005e-07 0.9 4.863e-07 0.9 4.86305e-07 0 4.866e-07 0 4.86605e-07 0.9 4.878e-07 0.9 4.87805e-07 0 4.881e-07 0 4.88105e-07 0.9 4.896e-07 0.9 4.89605e-07 0 4.899e-07 0 4.89905e-07 0.9 4.914e-07 0.9 4.91405e-07 0 4.917e-07 0 4.91705e-07 0.9 4.932e-07 0.9 4.93205e-07 0 4.935e-07 0 4.93505e-07 0.9 4.947e-07 0.9 4.94705e-07 0 4.95e-07 0 4.95005e-07 0.9 4.953e-07 0.9 4.95305e-07 0 4.956e-07 0 4.95605e-07 0.9 4.959e-07 0.9 4.95905e-07 0 4.968e-07 0 4.96805e-07 0.9 4.971e-07 0.9 4.97105e-07 0 4.974e-07 0 4.97405e-07 0.9 4.986e-07 0.9 4.98605e-07 0 4.989e-07 0 4.98905e-07 0.9 5.004e-07 0.9 5.00405e-07 0 5.007e-07 0 5.00705e-07 0.9 5.019e-07 0.9 5.01905e-07 0 5.022e-07 0 5.02205e-07 0.9 5.025e-07 0.9 5.02505e-07 0 5.028e-07 0 5.02805e-07 0.9 5.04e-07 0.9 5.04005e-07 0 5.043e-07 0 5.04305e-07 0.9 5.046e-07 0.9 5.04605e-07 0 5.049e-07 0 5.04905e-07 0.9 5.052e-07 0.9 5.05205e-07 0 5.061e-07 0 5.06105e-07 0.9 5.064e-07 0.9 5.06405e-07 0 5.067e-07 0 5.06705e-07 0.9 5.07e-07 0.9 5.07005e-07 0 5.079e-07 0 5.07905e-07 0.9 5.082e-07 0.9 5.08205e-07 0 5.085e-07 0 5.08505e-07 0.9 5.097e-07 0.9 5.09705e-07 0 5.1e-07 0 5.10005e-07 0.9 5.115e-07 0.9 5.11505e-07 0 5.118e-07 0 5.11805e-07 0.9 5.133e-07 0.9 5.13305e-07 0 5.136e-07 0 5.13605e-07 0.9 5.151e-07 0.9 5.15105e-07 0 5.154e-07 0 5.15405e-07 0.9 5.166e-07 0.9 5.16605e-07 0 5.169e-07 0 5.16905e-07 0.9 5.172e-07 0.9 5.17205e-07 0 5.175e-07 0 5.17505e-07 0.9 5.178e-07 0.9 5.17805e-07 0 5.187e-07 0 5.18705e-07 0.9 5.19e-07 0.9 5.19005e-07 0 5.193e-07 0 5.19305e-07 0.9 5.205e-07 0.9 5.20505e-07 0 5.208e-07 0 5.20805e-07 0.9 5.223e-07 0.9 5.22305e-07 0 5.226e-07 0 5.22605e-07 0.9 5.238e-07 0.9 5.23805e-07 0 5.241e-07 0 5.24105e-07 0.9 5.244e-07 0.9 5.24405e-07 0 5.247e-07 0 5.24705e-07 0.9 5.259e-07 0.9 5.25905e-07 0 5.262e-07 0 5.26205e-07 0.9 5.265e-07 0.9 5.26505e-07 0 5.268e-07 0 5.26805e-07 0.9 5.271e-07 0.9 5.27105e-07 0 5.28e-07 0 5.28005e-07 0.9 5.283e-07 0.9 5.28305e-07 0 5.286e-07 0 5.28605e-07 0.9 5.289e-07 0.9 5.28905e-07 0 5.298e-07 0 5.29805e-07 0.9 5.301e-07 0.9 5.30105e-07 0 5.304e-07 0 5.30405e-07 0.9 5.316e-07 0.9 5.31605e-07 0 5.319e-07 0 5.31905e-07 0.9 5.334e-07 0.9 5.33405e-07 0 5.337e-07 0 5.33705e-07 0.9 5.352e-07 0.9 5.35205e-07 0 5.355e-07 0 5.35505e-07 0.9 5.37e-07 0.9 5.37005e-07 0 5.373e-07 0 5.37305e-07 0.9 5.385e-07 0.9 5.38505e-07 0 5.388e-07 0 5.38805e-07 0.9 5.391e-07 0.9 5.39105e-07 0 5.394e-07 0 5.39405e-07 0.9 5.397e-07 0.9 5.39705e-07 0 5.406e-07 0 5.40605e-07 0.9 5.409e-07 0.9 5.40905e-07 0 5.412e-07 0 5.41205e-07 0.9 5.424e-07 0.9 5.42405e-07 0 5.427e-07 0 5.42705e-07 0.9 5.442e-07 0.9 5.44205e-07 0 5.445e-07 0 5.44505e-07 0.9 5.457e-07 0.9 5.45705e-07 0 5.46e-07 0 5.46005e-07 0.9 5.463e-07 0.9 5.46305e-07 0 5.466e-07 0 5.46605e-07 0.9 5.478e-07 0.9 5.47805e-07 0 5.481e-07 0 5.48105e-07 0.9 5.484e-07 0.9 5.48405e-07 0 5.487e-07 0 5.48705e-07 0.9 5.49e-07 0.9 5.49005e-07 0 5.499e-07 0 5.49905e-07 0.9 5.502e-07 0.9 5.50205e-07 0 5.505e-07 0 5.50505e-07 0.9 5.508e-07 0.9 5.50805e-07 0 5.517e-07 0 5.51705e-07 0.9 5.52e-07 0.9 5.52005e-07 0 5.523e-07 0 5.52305e-07 0.9 5.535e-07 0.9 5.53505e-07 0 5.538e-07 0 5.53805e-07 0.9 5.553e-07 0.9 5.55305e-07 0 5.556e-07 0 5.55605e-07 0.9 5.571e-07 0.9 5.57105e-07 0 5.574e-07 0 5.57405e-07 0.9 5.589e-07 0.9 5.58905e-07 0 5.592e-07 0 5.59205e-07 0.9 5.604e-07 0.9 5.60405e-07 0 5.607e-07 0 5.60705e-07 0.9 5.61e-07 0.9 5.61005e-07 0 5.613e-07 0 5.61305e-07 0.9 5.616e-07 0.9 5.61605e-07 0 5.625e-07 0 5.62505e-07 0.9 5.628e-07 0.9 5.62805e-07 0 5.631e-07 0 5.63105e-07 0.9 5.643e-07 0.9 5.64305e-07 0 5.646e-07 0 5.64605e-07 0.9 5.661e-07 0.9 5.66105e-07 0 5.664e-07 0 5.66405e-07 0.9 5.676e-07 0.9 5.67605e-07 0 5.679e-07 0 5.67905e-07 0.9 5.682e-07 0.9 5.68205e-07 0 5.685e-07 0 5.68505e-07 0.9 5.697e-07 0.9 5.69705e-07 0 5.7e-07 0 5.70005e-07 0.9 5.703e-07 0.9 5.70305e-07 0 5.706e-07 0 5.70605e-07 0.9 5.709e-07 0.9 5.70905e-07 0 5.718e-07 0 5.71805e-07 0.9 5.721e-07 0.9 5.72105e-07 0 5.724e-07 0 5.72405e-07 0.9 5.727e-07 0.9 5.72705e-07 0 5.736e-07 0 5.73605e-07 0.9 5.739e-07 0.9 5.73905e-07 0 5.742e-07 0 5.74205e-07 0.9 5.754e-07 0.9 5.75405e-07 0 5.757e-07 0 5.75705e-07 0.9 5.772e-07 0.9 5.77205e-07 0 5.775e-07 0 5.77505e-07 0.9 5.79e-07 0.9 5.79005e-07 0 5.793e-07 0 5.79305e-07 0.9 5.808e-07 0.9 5.80805e-07 0 5.811e-07 0 5.81105e-07 0.9 5.823e-07 0.9 5.82305e-07 0 5.826e-07 0 5.82605e-07 0.9 5.829e-07 0.9 5.82905e-07 0 5.832e-07 0 5.83205e-07 0.9 5.835e-07 0.9 5.83505e-07 0 5.844e-07 0 5.84405e-07 0.9 5.847e-07 0.9 5.84705e-07 0 5.85e-07 0 5.85005e-07 0.9 5.862e-07 0.9 5.86205e-07 0 5.865e-07 0 5.86505e-07 0.9 5.88e-07 0.9 5.88005e-07 0 5.883e-07 0 5.88305e-07 0.9 5.895e-07 0.9 5.89505e-07 0 5.898e-07 0 5.89805e-07 0.9 5.901e-07 0.9 5.90105e-07 0 5.904e-07 0 5.90405e-07 0.9]
MDN3 (i3 src3 0 0) nmos_rvt l=20n nfin=1
MDP3 (i3 src3 vdd vdd) pmos_rvt l=20n nfin=2
VS4 (src4 0) vsource type=pwl wave=[0 0.9 1.971e-07 0.9 1.97105e-07 0]
MDN4 (i4 src4 0 0) nmos_rvt l=20n nfin=1
MDP4 (i4 src4 vdd vdd) pmos_rvt l=20n nfin=2
VS5 (src5 0) vsource type=pwl wave=[0 0.9 3.942e-07 0.9 3.94205e-07 0]
MDN5 (i5 src5 0 0) nmos_rvt l=20n nfin=1
MDP5 (i5 src5 vdd vdd) pmos_rvt l=20n nfin=2
VS6 (src6 0) vsource type=pwl wave=[0 0.9 6.57e-08 0.9 6.5705e-08 0 1.971e-07 0 1.97105e-07 0.9 2.628e-07 0.9 2.62805e-07 0 3.942e-07 0 3.94205e-07 0.9 4.599e-07 0.9 4.59905e-07 0]
MDN6 (i6 src6 0 0) nmos_rvt l=20n nfin=1
MDP6 (i6 src6 vdd vdd) pmos_rvt l=20n nfin=2
VS7 (src7 0) vsource type=pwl wave=[0 0.9 1.314e-07 0.9 1.31405e-07 0 1.971e-07 0 1.97105e-07 0.9 3.285e-07 0.9 3.28505e-07 0 3.942e-07 0 3.94205e-07 0.9 5.256e-07 0.9 5.25605e-07 0]
MDN7 (i7 src7 0 0) nmos_rvt l=20n nfin=1
MDP7 (i7 src7 vdd vdd) pmos_rvt l=20n nfin=2
VS8 (src8 0) vsource type=pwl wave=[0 0.9 2.19e-08 0.9 2.1905e-08 0 6.57e-08 0 6.5705e-08 0.9 8.76e-08 0.9 8.7605e-08 0 1.314e-07 0 1.31405e-07 0.9 1.533e-07 0.9 1.53305e-07 0 1.971e-07 0 1.97105e-07 0.9 2.19e-07 0.9 2.19005e-07 0 2.628e-07 0 2.62805e-07 0.9 2.847e-07 0.9 2.84705e-07 0 3.285e-07 0 3.28505e-07 0.9 3.504e-07 0.9 3.50405e-07 0 3.942e-07 0 3.94205e-07 0.9 4.161e-07 0.9 4.16105e-07 0 4.599e-07 0 4.59905e-07 0.9 4.818e-07 0.9 4.81805e-07 0 5.256e-07 0 5.25605e-07 0.9 5.475e-07 0.9 5.47505e-07 0]
MDN8 (i8 src8 0 0) nmos_rvt l=20n nfin=1
MDP8 (i8 src8 vdd vdd) pmos_rvt l=20n nfin=2
VS9 (src9 0) vsource type=pwl wave=[0 0.9 4.38e-08 0.9 4.3805e-08 0 6.57e-08 0 6.5705e-08 0.9 1.095e-07 0.9 1.09505e-07 0 1.314e-07 0 1.31405e-07 0.9 1.752e-07 0.9 1.75205e-07 0 1.971e-07 0 1.97105e-07 0.9 2.409e-07 0.9 2.40905e-07 0 2.628e-07 0 2.62805e-07 0.9 3.066e-07 0.9 3.06605e-07 0 3.285e-07 0 3.28505e-07 0.9 3.723e-07 0.9 3.72305e-07 0 3.942e-07 0 3.94205e-07 0.9 4.38e-07 0.9 4.38005e-07 0 4.599e-07 0 4.59905e-07 0.9 5.037e-07 0.9 5.03705e-07 0 5.256e-07 0 5.25605e-07 0.9 5.694e-07 0.9 5.69405e-07 0]
MDN9 (i9 src9 0 0) nmos_rvt l=20n nfin=1
MDP9 (i9 src9 vdd vdd) pmos_rvt l=20n nfin=2
CL0 (n18 0) capacitor c=1f
CL1 (n19 0) capacitor c=1f
tran tran stop=5.913e-07 maxstep=1.0p errpreset=conservative
save i0 i1 i2 i3 i4 i5 i6 i7 i8 i9 n18 n19 VDD:p
