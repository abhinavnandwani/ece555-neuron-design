.SUBCKT neuron_mirror_n3_p3 i0 i1 i2 i3 i4 i5 i6 i7 i8 i9 n18 n19 VDD VSS
M1 n0 i0 j1 VSS nmos_rvt L=20n W=81n nfin=3
M2 j1 i4 VSS VSS nmos_rvt L=20n W=81n nfin=3
M3 n0 i0 VDD VDD pmos_rvt L=20n W=81n nfin=3
M4 n0 i4 VDD VDD pmos_rvt L=20n W=81n nfin=3
M5 n1 n0 VSS VSS nmos_rvt L=20n W=81n nfin=3
M6 n1 n0 VDD VDD pmos_rvt L=20n W=81n nfin=3
M7 n2 i1 j3 VSS nmos_rvt L=20n W=81n nfin=3
M8 j3 i5 VSS VSS nmos_rvt L=20n W=81n nfin=3
M9 n2 i1 VDD VDD pmos_rvt L=20n W=81n nfin=3
M10 n2 i5 VDD VDD pmos_rvt L=20n W=81n nfin=3
M11 n3 i1 j5 VSS nmos_rvt L=20n W=81n nfin=3
M12 n3 i5 j5 VSS nmos_rvt L=20n W=81n nfin=3
M13 j5 n2 VSS VSS nmos_rvt L=20n W=81n nfin=3
M14 n3 i1 j7 VDD pmos_rvt L=20n W=81n nfin=3
M15 j7 i5 VDD VDD pmos_rvt L=20n W=81n nfin=3
M16 n3 n2 VDD VDD pmos_rvt L=20n W=81n nfin=3
M17 n4 n0 VSS VSS nmos_rvt L=20n W=81n nfin=3
M18 n4 n3 VSS VSS nmos_rvt L=20n W=81n nfin=3
M19 n4 n0 j9 VDD pmos_rvt L=20n W=81n nfin=3
M20 j9 n3 VDD VDD pmos_rvt L=20n W=81n nfin=3
M21 n5 i2 j11 VSS nmos_rvt L=20n W=81n nfin=3
M22 j11 i6 VSS VSS nmos_rvt L=20n W=81n nfin=3
M23 n5 i2 VDD VDD pmos_rvt L=20n W=81n nfin=3
M24 n5 i6 VDD VDD pmos_rvt L=20n W=81n nfin=3
M25 n6 n5 VSS VSS nmos_rvt L=20n W=81n nfin=3
M26 n6 n5 VDD VDD pmos_rvt L=20n W=81n nfin=3
M27 n7 i3 j13 VSS nmos_rvt L=20n W=81n nfin=3
M28 j13 i7 VSS VSS nmos_rvt L=20n W=81n nfin=3
M29 n7 i3 VDD VDD pmos_rvt L=20n W=81n nfin=3
M30 n7 i7 VDD VDD pmos_rvt L=20n W=81n nfin=3
M31 n8 i3 j15 VSS nmos_rvt L=20n W=81n nfin=3
M32 n8 i7 j15 VSS nmos_rvt L=20n W=81n nfin=3
M33 j15 n7 VSS VSS nmos_rvt L=20n W=81n nfin=3
M34 n8 i3 j17 VDD pmos_rvt L=20n W=81n nfin=3
M35 j17 i7 VDD VDD pmos_rvt L=20n W=81n nfin=3
M36 n8 n7 VDD VDD pmos_rvt L=20n W=81n nfin=3
M37 n9 n5 VSS VSS nmos_rvt L=20n W=81n nfin=3
M38 n9 n8 VSS VSS nmos_rvt L=20n W=81n nfin=3
M39 n9 n5 j19 VDD pmos_rvt L=20n W=81n nfin=3
M40 j19 n8 VDD VDD pmos_rvt L=20n W=81n nfin=3
M41 n10 n1 j21 VSS nmos_rvt L=20n W=81n nfin=3
M42 j21 n6 VSS VSS nmos_rvt L=20n W=81n nfin=3
M43 n10 i8 j23 VSS nmos_rvt L=20n W=81n nfin=3
M44 j23 n1 VSS VSS nmos_rvt L=20n W=81n nfin=3
M45 j23 n6 VSS VSS nmos_rvt L=20n W=81n nfin=3
M46 n10 n1 j25 VDD pmos_rvt L=20n W=81n nfin=3
M47 n10 n6 j25 VDD pmos_rvt L=20n W=81n nfin=3
M48 j25 i8 VDD VDD pmos_rvt L=20n W=81n nfin=3
M49 j25 n1 j27 VDD pmos_rvt L=20n W=81n nfin=3
M50 j27 n6 VDD VDD pmos_rvt L=20n W=81n nfin=3
M51 n11 n1 j29 VSS nmos_rvt L=20n W=81n nfin=3
M52 j29 n6 j30 VSS nmos_rvt L=20n W=81n nfin=3
M53 j30 i8 VSS VSS nmos_rvt L=20n W=81n nfin=3
M54 n11 n10 j32 VSS nmos_rvt L=20n W=81n nfin=3
M55 j32 n1 VSS VSS nmos_rvt L=20n W=81n nfin=3
M56 j32 n6 VSS VSS nmos_rvt L=20n W=81n nfin=3
M57 j32 i8 VSS VSS nmos_rvt L=20n W=81n nfin=3
M58 n11 n1 j34 VDD pmos_rvt L=20n W=81n nfin=3
M59 n11 n6 j34 VDD pmos_rvt L=20n W=81n nfin=3
M60 n11 i8 j34 VDD pmos_rvt L=20n W=81n nfin=3
M61 j34 n10 VDD VDD pmos_rvt L=20n W=81n nfin=3
M62 j34 n1 j36 VDD pmos_rvt L=20n W=81n nfin=3
M63 j36 n6 j37 VDD pmos_rvt L=20n W=81n nfin=3
M64 j37 i8 VDD VDD pmos_rvt L=20n W=81n nfin=3
M65 n14 n4 j39 VSS nmos_rvt L=20n W=81n nfin=3
M66 j39 n9 VSS VSS nmos_rvt L=20n W=81n nfin=3
M67 n14 i9 j41 VSS nmos_rvt L=20n W=81n nfin=3
M68 j41 n4 VSS VSS nmos_rvt L=20n W=81n nfin=3
M69 j41 n9 VSS VSS nmos_rvt L=20n W=81n nfin=3
M70 n14 n4 j43 VDD pmos_rvt L=20n W=81n nfin=3
M71 n14 n9 j43 VDD pmos_rvt L=20n W=81n nfin=3
M72 j43 i9 VDD VDD pmos_rvt L=20n W=81n nfin=3
M73 j43 n4 j45 VDD pmos_rvt L=20n W=81n nfin=3
M74 j45 n9 VDD VDD pmos_rvt L=20n W=81n nfin=3
M75 n15 n4 j47 VSS nmos_rvt L=20n W=81n nfin=3
M76 j47 n9 j48 VSS nmos_rvt L=20n W=81n nfin=3
M77 j48 i9 VSS VSS nmos_rvt L=20n W=81n nfin=3
M78 n15 n14 j50 VSS nmos_rvt L=20n W=81n nfin=3
M79 j50 n4 VSS VSS nmos_rvt L=20n W=81n nfin=3
M80 j50 n9 VSS VSS nmos_rvt L=20n W=81n nfin=3
M81 j50 i9 VSS VSS nmos_rvt L=20n W=81n nfin=3
M82 n15 n4 j52 VDD pmos_rvt L=20n W=81n nfin=3
M83 n15 n9 j52 VDD pmos_rvt L=20n W=81n nfin=3
M84 n15 i9 j52 VDD pmos_rvt L=20n W=81n nfin=3
M85 j52 n14 VDD VDD pmos_rvt L=20n W=81n nfin=3
M86 j52 n4 j54 VDD pmos_rvt L=20n W=81n nfin=3
M87 j54 n9 j55 VDD pmos_rvt L=20n W=81n nfin=3
M88 j55 i9 VDD VDD pmos_rvt L=20n W=81n nfin=3
M89 n16 n15 VSS VSS nmos_rvt L=20n W=81n nfin=3
M90 n16 n15 VDD VDD pmos_rvt L=20n W=81n nfin=3
M91 n17 n14 VSS VSS nmos_rvt L=20n W=81n nfin=3
M92 n17 n14 VDD VDD pmos_rvt L=20n W=81n nfin=3
M93 n18 n10 j57 VSS nmos_rvt L=20n W=81n nfin=3
M94 j57 n16 VSS VSS nmos_rvt L=20n W=81n nfin=3
M95 n18 n11 VSS VSS nmos_rvt L=20n W=81n nfin=3
M96 n18 n17 VSS VSS nmos_rvt L=20n W=81n nfin=3
M97 n18 n10 j59 VDD pmos_rvt L=20n W=81n nfin=3
M98 n18 n16 j59 VDD pmos_rvt L=20n W=81n nfin=3
M99 j59 n11 j60 VDD pmos_rvt L=20n W=81n nfin=3
M100 j60 n17 VDD VDD pmos_rvt L=20n W=81n nfin=3
M101 n19 n10 VSS VSS nmos_rvt L=20n W=81n nfin=3
M102 n19 n16 VSS VSS nmos_rvt L=20n W=81n nfin=3
M103 n19 n17 VSS VSS nmos_rvt L=20n W=81n nfin=3
M104 n19 n10 j62 VDD pmos_rvt L=20n W=81n nfin=3
M105 j62 n16 j63 VDD pmos_rvt L=20n W=81n nfin=3
M106 j63 n17 VDD VDD pmos_rvt L=20n W=81n nfin=3
.ENDS
