* SPICE NETLIST
***************************************

.SUBCKT neuron_mirror_n1_p6 i0 i4 i1 i5 i2 i6 i3 i7 i8 i9 VSS VDD n18 n19
** N=146 EP=14 IP=0 FDC=106
M0 44 i0 3 VSS nmos_rvt L=2e-08 W=2.7e-08 nfin=1 $X=716 $Y=756 $D=1
M1 VSS i4 44 VSS nmos_rvt L=2e-08 W=2.7e-08 nfin=1 $X=932 $Y=756 $D=1
M2 VSS 3 15 VSS nmos_rvt L=2e-08 W=2.7e-08 nfin=1 $X=1580 $Y=756 $D=1
M3 45 i1 6 VSS nmos_rvt L=2e-08 W=2.7e-08 nfin=1 $X=2228 $Y=756 $D=1
M4 VSS i5 45 VSS nmos_rvt L=2e-08 W=2.7e-08 nfin=1 $X=2444 $Y=756 $D=1
M5 7 i1 29 VSS nmos_rvt L=2e-08 W=2.7e-08 nfin=1 $X=3092 $Y=756 $D=1
M6 29 i5 7 VSS nmos_rvt L=2e-08 W=2.7e-08 nfin=1 $X=3308 $Y=756 $D=1
M7 VSS 6 29 VSS nmos_rvt L=2e-08 W=2.7e-08 nfin=1 $X=3524 $Y=756 $D=1
M8 VSS 3 19 VSS nmos_rvt L=2e-08 W=2.7e-08 nfin=1 $X=4172 $Y=756 $D=1
M9 19 7 VSS VSS nmos_rvt L=2e-08 W=2.7e-08 nfin=1 $X=4388 $Y=756 $D=1
M10 46 i2 10 VSS nmos_rvt L=2e-08 W=2.7e-08 nfin=1 $X=5036 $Y=756 $D=1
M11 VSS i6 46 VSS nmos_rvt L=2e-08 W=2.7e-08 nfin=1 $X=5252 $Y=756 $D=1
M12 VSS 10 16 VSS nmos_rvt L=2e-08 W=2.7e-08 nfin=1 $X=5900 $Y=756 $D=1
M13 47 i3 13 VSS nmos_rvt L=2e-08 W=2.7e-08 nfin=1 $X=6548 $Y=756 $D=1
M14 VSS i7 47 VSS nmos_rvt L=2e-08 W=2.7e-08 nfin=1 $X=6764 $Y=756 $D=1
M15 14 i3 30 VSS nmos_rvt L=2e-08 W=2.7e-08 nfin=1 $X=7412 $Y=756 $D=1
M16 30 i7 14 VSS nmos_rvt L=2e-08 W=2.7e-08 nfin=1 $X=7628 $Y=756 $D=1
M17 VSS 13 30 VSS nmos_rvt L=2e-08 W=2.7e-08 nfin=1 $X=7844 $Y=756 $D=1
M18 VSS 10 20 VSS nmos_rvt L=2e-08 W=2.7e-08 nfin=1 $X=8492 $Y=756 $D=1
M19 20 14 VSS VSS nmos_rvt L=2e-08 W=2.7e-08 nfin=1 $X=8708 $Y=756 $D=1
M20 VSS 15 31 VSS nmos_rvt L=2e-08 W=2.7e-08 nfin=1 $X=9356 $Y=756 $D=1
M21 48 16 VSS VSS nmos_rvt L=2e-08 W=2.7e-08 nfin=1 $X=9572 $Y=756 $D=1
M22 18 15 48 VSS nmos_rvt L=2e-08 W=2.7e-08 nfin=1 $X=9788 $Y=756 $D=1
M23 31 i8 18 VSS nmos_rvt L=2e-08 W=2.7e-08 nfin=1 $X=10004 $Y=756 $D=1
M24 VSS 16 31 VSS nmos_rvt L=2e-08 W=2.7e-08 nfin=1 $X=10220 $Y=756 $D=1
M25 49 15 25 VSS nmos_rvt L=2e-08 W=2.7e-08 nfin=1 $X=10868 $Y=756 $D=1
M26 50 16 49 VSS nmos_rvt L=2e-08 W=2.7e-08 nfin=1 $X=11084 $Y=756 $D=1
M27 VSS i8 50 VSS nmos_rvt L=2e-08 W=2.7e-08 nfin=1 $X=11300 $Y=756 $D=1
M28 35 15 VSS VSS nmos_rvt L=2e-08 W=2.7e-08 nfin=1 $X=11516 $Y=756 $D=1
M29 VSS 16 35 VSS nmos_rvt L=2e-08 W=2.7e-08 nfin=1 $X=11732 $Y=756 $D=1
M30 35 i8 VSS VSS nmos_rvt L=2e-08 W=2.7e-08 nfin=1 $X=11948 $Y=756 $D=1
M31 25 18 35 VSS nmos_rvt L=2e-08 W=2.7e-08 nfin=1 $X=12164 $Y=756 $D=1
M32 VSS 19 36 VSS nmos_rvt L=2e-08 W=2.7e-08 nfin=1 $X=12812 $Y=756 $D=1
M33 51 20 VSS VSS nmos_rvt L=2e-08 W=2.7e-08 nfin=1 $X=13028 $Y=756 $D=1
M34 22 19 51 VSS nmos_rvt L=2e-08 W=2.7e-08 nfin=1 $X=13244 $Y=756 $D=1
M35 36 i9 22 VSS nmos_rvt L=2e-08 W=2.7e-08 nfin=1 $X=13460 $Y=756 $D=1
M36 VSS 20 36 VSS nmos_rvt L=2e-08 W=2.7e-08 nfin=1 $X=13676 $Y=756 $D=1
M37 52 19 23 VSS nmos_rvt L=2e-08 W=2.7e-08 nfin=1 $X=14324 $Y=756 $D=1
M38 53 20 52 VSS nmos_rvt L=2e-08 W=2.7e-08 nfin=1 $X=14540 $Y=756 $D=1
M39 VSS i9 53 VSS nmos_rvt L=2e-08 W=2.7e-08 nfin=1 $X=14756 $Y=756 $D=1
M40 40 19 VSS VSS nmos_rvt L=2e-08 W=2.7e-08 nfin=1 $X=14972 $Y=756 $D=1
M41 VSS 20 40 VSS nmos_rvt L=2e-08 W=2.7e-08 nfin=1 $X=15188 $Y=756 $D=1
M42 40 i9 VSS VSS nmos_rvt L=2e-08 W=2.7e-08 nfin=1 $X=15404 $Y=756 $D=1
M43 23 22 40 VSS nmos_rvt L=2e-08 W=2.7e-08 nfin=1 $X=15620 $Y=756 $D=1
M44 VSS 23 24 VSS nmos_rvt L=2e-08 W=2.7e-08 nfin=1 $X=16268 $Y=756 $D=1
M45 VSS 22 26 VSS nmos_rvt L=2e-08 W=2.7e-08 nfin=1 $X=16916 $Y=756 $D=1
M46 54 18 n18 VSS nmos_rvt L=2e-08 W=2.7e-08 nfin=1 $X=17564 $Y=756 $D=1
M47 VSS 24 54 VSS nmos_rvt L=2e-08 W=2.7e-08 nfin=1 $X=17780 $Y=756 $D=1
M48 n18 25 VSS VSS nmos_rvt L=2e-08 W=2.7e-08 nfin=1 $X=17996 $Y=756 $D=1
M49 VSS 26 n18 VSS nmos_rvt L=2e-08 W=2.7e-08 nfin=1 $X=18212 $Y=756 $D=1
M50 VSS 18 n19 VSS nmos_rvt L=2e-08 W=2.7e-08 nfin=1 $X=18860 $Y=756 $D=1
M51 n19 24 VSS VSS nmos_rvt L=2e-08 W=2.7e-08 nfin=1 $X=19076 $Y=756 $D=1
M52 VSS 26 n19 VSS nmos_rvt L=2e-08 W=2.7e-08 nfin=1 $X=19292 $Y=756 $D=1
M53 VDD i0 3 VDD pmos_rvt L=2e-08 W=1.62e-07 nfin=6 $X=716 $Y=1728 $D=0
M54 3 i4 VDD VDD pmos_rvt L=2e-08 W=1.62e-07 nfin=6 $X=932 $Y=1728 $D=0
M55 VDD 3 15 VDD pmos_rvt L=2e-08 W=1.62e-07 nfin=6 $X=1580 $Y=1728 $D=0
M56 VDD i1 6 VDD pmos_rvt L=2e-08 W=1.62e-07 nfin=6 $X=2228 $Y=1728 $D=0
M57 6 i5 VDD VDD pmos_rvt L=2e-08 W=1.62e-07 nfin=6 $X=2444 $Y=1728 $D=0
M58 55 i1 7 VDD pmos_rvt L=2e-08 W=1.62e-07 nfin=6 $X=3092 $Y=1728 $D=0
M59 VDD i5 55 VDD pmos_rvt L=2e-08 W=1.62e-07 nfin=6 $X=3308 $Y=1728 $D=0
M60 7 6 VDD VDD pmos_rvt L=2e-08 W=1.62e-07 nfin=6 $X=3524 $Y=1728 $D=0
M61 56 3 19 VDD pmos_rvt L=2e-08 W=1.62e-07 nfin=6 $X=4172 $Y=1728 $D=0
M62 VDD 7 56 VDD pmos_rvt L=2e-08 W=1.62e-07 nfin=6 $X=4388 $Y=1728 $D=0
M63 VDD i2 10 VDD pmos_rvt L=2e-08 W=1.62e-07 nfin=6 $X=5036 $Y=1728 $D=0
M64 10 i6 VDD VDD pmos_rvt L=2e-08 W=1.62e-07 nfin=6 $X=5252 $Y=1728 $D=0
M65 VDD 10 16 VDD pmos_rvt L=2e-08 W=1.62e-07 nfin=6 $X=5900 $Y=1728 $D=0
M66 VDD i3 13 VDD pmos_rvt L=2e-08 W=1.62e-07 nfin=6 $X=6548 $Y=1728 $D=0
M67 13 i7 VDD VDD pmos_rvt L=2e-08 W=1.62e-07 nfin=6 $X=6764 $Y=1728 $D=0
M68 57 i3 14 VDD pmos_rvt L=2e-08 W=1.62e-07 nfin=6 $X=7412 $Y=1728 $D=0
M69 VDD i7 57 VDD pmos_rvt L=2e-08 W=1.62e-07 nfin=6 $X=7628 $Y=1728 $D=0
M70 14 13 VDD VDD pmos_rvt L=2e-08 W=1.62e-07 nfin=6 $X=7844 $Y=1728 $D=0
M71 58 10 20 VDD pmos_rvt L=2e-08 W=1.62e-07 nfin=6 $X=8492 $Y=1728 $D=0
M72 VDD 14 58 VDD pmos_rvt L=2e-08 W=1.62e-07 nfin=6 $X=8708 $Y=1728 $D=0
M73 33 15 32 VDD pmos_rvt L=2e-08 W=1.62e-07 nfin=6 $X=9356 $Y=1728 $D=0
M74 18 16 33 VDD pmos_rvt L=2e-08 W=1.62e-07 nfin=6 $X=9572 $Y=1728 $D=0
M75 33 15 18 VDD pmos_rvt L=2e-08 W=1.62e-07 nfin=6 $X=9788 $Y=1728 $D=0
M76 VDD i8 33 VDD pmos_rvt L=2e-08 W=1.62e-07 nfin=6 $X=10004 $Y=1728 $D=0
M77 32 16 VDD VDD pmos_rvt L=2e-08 W=1.62e-07 nfin=6 $X=10220 $Y=1728 $D=0
M78 34 15 25 VDD pmos_rvt L=2e-08 W=1.62e-07 nfin=6 $X=10868 $Y=1728 $D=0
M79 25 16 34 VDD pmos_rvt L=2e-08 W=1.62e-07 nfin=6 $X=11084 $Y=1728 $D=0
M80 34 i8 25 VDD pmos_rvt L=2e-08 W=1.62e-07 nfin=6 $X=11300 $Y=1728 $D=0
M81 59 15 34 VDD pmos_rvt L=2e-08 W=1.62e-07 nfin=6 $X=11516 $Y=1728 $D=0
M82 60 16 59 VDD pmos_rvt L=2e-08 W=1.62e-07 nfin=6 $X=11732 $Y=1728 $D=0
M83 VDD i8 60 VDD pmos_rvt L=2e-08 W=1.62e-07 nfin=6 $X=11948 $Y=1728 $D=0
M84 34 18 VDD VDD pmos_rvt L=2e-08 W=1.62e-07 nfin=6 $X=12164 $Y=1728 $D=0
M85 38 19 37 VDD pmos_rvt L=2e-08 W=1.62e-07 nfin=6 $X=12812 $Y=1728 $D=0
M86 22 20 38 VDD pmos_rvt L=2e-08 W=1.62e-07 nfin=6 $X=13028 $Y=1728 $D=0
M87 38 19 22 VDD pmos_rvt L=2e-08 W=1.62e-07 nfin=6 $X=13244 $Y=1728 $D=0
M88 VDD i9 38 VDD pmos_rvt L=2e-08 W=1.62e-07 nfin=6 $X=13460 $Y=1728 $D=0
M89 37 20 VDD VDD pmos_rvt L=2e-08 W=1.62e-07 nfin=6 $X=13676 $Y=1728 $D=0
M90 39 19 23 VDD pmos_rvt L=2e-08 W=1.62e-07 nfin=6 $X=14324 $Y=1728 $D=0
M91 23 20 39 VDD pmos_rvt L=2e-08 W=1.62e-07 nfin=6 $X=14540 $Y=1728 $D=0
M92 39 i9 23 VDD pmos_rvt L=2e-08 W=1.62e-07 nfin=6 $X=14756 $Y=1728 $D=0
M93 61 19 39 VDD pmos_rvt L=2e-08 W=1.62e-07 nfin=6 $X=14972 $Y=1728 $D=0
M94 62 20 61 VDD pmos_rvt L=2e-08 W=1.62e-07 nfin=6 $X=15188 $Y=1728 $D=0
M95 VDD i9 62 VDD pmos_rvt L=2e-08 W=1.62e-07 nfin=6 $X=15404 $Y=1728 $D=0
M96 39 22 VDD VDD pmos_rvt L=2e-08 W=1.62e-07 nfin=6 $X=15620 $Y=1728 $D=0
M97 VDD 23 24 VDD pmos_rvt L=2e-08 W=1.62e-07 nfin=6 $X=16268 $Y=1728 $D=0
M98 VDD 22 26 VDD pmos_rvt L=2e-08 W=1.62e-07 nfin=6 $X=16916 $Y=1728 $D=0
M99 n18 18 42 VDD pmos_rvt L=2e-08 W=1.62e-07 nfin=6 $X=17564 $Y=1728 $D=0
M100 42 24 n18 VDD pmos_rvt L=2e-08 W=1.62e-07 nfin=6 $X=17780 $Y=1728 $D=0
M101 63 25 42 VDD pmos_rvt L=2e-08 W=1.62e-07 nfin=6 $X=17996 $Y=1728 $D=0
M102 VDD 26 63 VDD pmos_rvt L=2e-08 W=1.62e-07 nfin=6 $X=18212 $Y=1728 $D=0
M103 64 18 n19 VDD pmos_rvt L=2e-08 W=1.62e-07 nfin=6 $X=18860 $Y=1728 $D=0
M104 65 24 64 VDD pmos_rvt L=2e-08 W=1.62e-07 nfin=6 $X=19076 $Y=1728 $D=0
M105 VDD 26 65 VDD pmos_rvt L=2e-08 W=1.62e-07 nfin=6 $X=19292 $Y=1728 $D=0
.ENDS
***************************************
