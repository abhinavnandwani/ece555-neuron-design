* SPICE NETLIST
***************************************

.SUBCKT neuron_cmos_xor_n2_p2 i0 i4 i1 i5 i2 i6 i3 i7 i8 i9 VSS VDD n35 n39
** N=254 EP=14 IP=0 FDC=146
M0 59 i0 3 VSS nmos_rvt L=2e-08 W=5.4e-08 nfin=2 $X=716 $Y=756 $D=1
M1 VSS i4 59 VSS nmos_rvt L=2e-08 W=5.4e-08 nfin=2 $X=932 $Y=756 $D=1
M2 VSS 3 8 VSS nmos_rvt L=2e-08 W=5.4e-08 nfin=2 $X=1580 $Y=756 $D=1
M3 VSS i1 7 VSS nmos_rvt L=2e-08 W=5.4e-08 nfin=2 $X=2228 $Y=756 $D=1
M4 VSS i5 6 VSS nmos_rvt L=2e-08 W=5.4e-08 nfin=2 $X=2876 $Y=756 $D=1
M5 60 i1 9 VSS nmos_rvt L=2e-08 W=5.4e-08 nfin=2 $X=3524 $Y=756 $D=1
M6 VSS i5 60 VSS nmos_rvt L=2e-08 W=5.4e-08 nfin=2 $X=3740 $Y=756 $D=1
M7 61 6 VSS VSS nmos_rvt L=2e-08 W=5.4e-08 nfin=2 $X=3956 $Y=756 $D=1
M8 9 7 61 VSS nmos_rvt L=2e-08 W=5.4e-08 nfin=2 $X=4172 $Y=756 $D=1
M9 62 8 10 VSS nmos_rvt L=2e-08 W=5.4e-08 nfin=2 $X=4820 $Y=756 $D=1
M10 VSS 9 62 VSS nmos_rvt L=2e-08 W=5.4e-08 nfin=2 $X=5036 $Y=756 $D=1
M11 VSS 10 27 VSS nmos_rvt L=2e-08 W=5.4e-08 nfin=2 $X=5684 $Y=756 $D=1
M12 63 i2 13 VSS nmos_rvt L=2e-08 W=5.4e-08 nfin=2 $X=6332 $Y=756 $D=1
M13 VSS i6 63 VSS nmos_rvt L=2e-08 W=5.4e-08 nfin=2 $X=6548 $Y=756 $D=1
M14 VSS 13 18 VSS nmos_rvt L=2e-08 W=5.4e-08 nfin=2 $X=7196 $Y=756 $D=1
M15 VSS i3 17 VSS nmos_rvt L=2e-08 W=5.4e-08 nfin=2 $X=7844 $Y=756 $D=1
M16 VSS i7 16 VSS nmos_rvt L=2e-08 W=5.4e-08 nfin=2 $X=8492 $Y=756 $D=1
M17 64 i3 19 VSS nmos_rvt L=2e-08 W=5.4e-08 nfin=2 $X=9140 $Y=756 $D=1
M18 VSS i7 64 VSS nmos_rvt L=2e-08 W=5.4e-08 nfin=2 $X=9356 $Y=756 $D=1
M19 65 16 VSS VSS nmos_rvt L=2e-08 W=5.4e-08 nfin=2 $X=9572 $Y=756 $D=1
M20 19 17 65 VSS nmos_rvt L=2e-08 W=5.4e-08 nfin=2 $X=9788 $Y=756 $D=1
M21 66 18 20 VSS nmos_rvt L=2e-08 W=5.4e-08 nfin=2 $X=10436 $Y=756 $D=1
M22 VSS 19 66 VSS nmos_rvt L=2e-08 W=5.4e-08 nfin=2 $X=10652 $Y=756 $D=1
M23 VSS 20 28 VSS nmos_rvt L=2e-08 W=5.4e-08 nfin=2 $X=11300 $Y=756 $D=1
M24 67 8 21 VSS nmos_rvt L=2e-08 W=5.4e-08 nfin=2 $X=11948 $Y=756 $D=1
M25 VSS 18 67 VSS nmos_rvt L=2e-08 W=5.4e-08 nfin=2 $X=12164 $Y=756 $D=1
M26 68 13 VSS VSS nmos_rvt L=2e-08 W=5.4e-08 nfin=2 $X=12380 $Y=756 $D=1
M27 21 3 68 VSS nmos_rvt L=2e-08 W=5.4e-08 nfin=2 $X=12596 $Y=756 $D=1
M28 VSS 21 24 VSS nmos_rvt L=2e-08 W=5.4e-08 nfin=2 $X=13244 $Y=756 $D=1
M29 VSS i8 23 VSS nmos_rvt L=2e-08 W=5.4e-08 nfin=2 $X=13892 $Y=756 $D=1
M30 69 21 43 VSS nmos_rvt L=2e-08 W=5.4e-08 nfin=2 $X=14540 $Y=756 $D=1
M31 VSS i8 69 VSS nmos_rvt L=2e-08 W=5.4e-08 nfin=2 $X=14756 $Y=756 $D=1
M32 70 23 VSS VSS nmos_rvt L=2e-08 W=5.4e-08 nfin=2 $X=14972 $Y=756 $D=1
M33 43 24 70 VSS nmos_rvt L=2e-08 W=5.4e-08 nfin=2 $X=15188 $Y=756 $D=1
M34 71 8 25 VSS nmos_rvt L=2e-08 W=5.4e-08 nfin=2 $X=15836 $Y=756 $D=1
M35 VSS 18 71 VSS nmos_rvt L=2e-08 W=5.4e-08 nfin=2 $X=16052 $Y=756 $D=1
M36 72 21 26 VSS nmos_rvt L=2e-08 W=5.4e-08 nfin=2 $X=16700 $Y=756 $D=1
M37 VSS i8 72 VSS nmos_rvt L=2e-08 W=5.4e-08 nfin=2 $X=16916 $Y=756 $D=1
M38 73 25 37 VSS nmos_rvt L=2e-08 W=5.4e-08 nfin=2 $X=17564 $Y=756 $D=1
M39 VSS 26 73 VSS nmos_rvt L=2e-08 W=5.4e-08 nfin=2 $X=17780 $Y=756 $D=1
M40 74 27 29 VSS nmos_rvt L=2e-08 W=5.4e-08 nfin=2 $X=18428 $Y=756 $D=1
M41 VSS 28 74 VSS nmos_rvt L=2e-08 W=5.4e-08 nfin=2 $X=18644 $Y=756 $D=1
M42 75 20 VSS VSS nmos_rvt L=2e-08 W=5.4e-08 nfin=2 $X=18860 $Y=756 $D=1
M43 29 10 75 VSS nmos_rvt L=2e-08 W=5.4e-08 nfin=2 $X=19076 $Y=756 $D=1
M44 VSS 29 32 VSS nmos_rvt L=2e-08 W=5.4e-08 nfin=2 $X=19724 $Y=756 $D=1
M45 VSS i9 31 VSS nmos_rvt L=2e-08 W=5.4e-08 nfin=2 $X=20372 $Y=756 $D=1
M46 76 29 36 VSS nmos_rvt L=2e-08 W=5.4e-08 nfin=2 $X=21020 $Y=756 $D=1
M47 VSS i9 76 VSS nmos_rvt L=2e-08 W=5.4e-08 nfin=2 $X=21236 $Y=756 $D=1
M48 77 31 VSS VSS nmos_rvt L=2e-08 W=5.4e-08 nfin=2 $X=21452 $Y=756 $D=1
M49 36 32 77 VSS nmos_rvt L=2e-08 W=5.4e-08 nfin=2 $X=21668 $Y=756 $D=1
M50 78 27 33 VSS nmos_rvt L=2e-08 W=5.4e-08 nfin=2 $X=22316 $Y=756 $D=1
M51 VSS 28 78 VSS nmos_rvt L=2e-08 W=5.4e-08 nfin=2 $X=22532 $Y=756 $D=1
M52 79 29 34 VSS nmos_rvt L=2e-08 W=5.4e-08 nfin=2 $X=23180 $Y=756 $D=1
M53 VSS i9 79 VSS nmos_rvt L=2e-08 W=5.4e-08 nfin=2 $X=23396 $Y=756 $D=1
M54 80 33 35 VSS nmos_rvt L=2e-08 W=5.4e-08 nfin=2 $X=24044 $Y=756 $D=1
M55 VSS 34 80 VSS nmos_rvt L=2e-08 W=5.4e-08 nfin=2 $X=24260 $Y=756 $D=1
M56 VSS 35 40 VSS nmos_rvt L=2e-08 W=5.4e-08 nfin=2 $X=24908 $Y=756 $D=1
M57 VSS 36 38 VSS nmos_rvt L=2e-08 W=5.4e-08 nfin=2 $X=25556 $Y=756 $D=1
M58 VSS 37 39 VSS nmos_rvt L=2e-08 W=5.4e-08 nfin=2 $X=26204 $Y=756 $D=1
M59 39 38 VSS VSS nmos_rvt L=2e-08 W=5.4e-08 nfin=2 $X=26420 $Y=756 $D=1
M60 VSS 39 41 VSS nmos_rvt L=2e-08 W=5.4e-08 nfin=2 $X=27068 $Y=756 $D=1
M61 81 40 42 VSS nmos_rvt L=2e-08 W=5.4e-08 nfin=2 $X=27716 $Y=756 $D=1
M62 VSS 41 81 VSS nmos_rvt L=2e-08 W=5.4e-08 nfin=2 $X=27932 $Y=756 $D=1
M63 VSS 42 44 VSS nmos_rvt L=2e-08 W=5.4e-08 nfin=2 $X=28580 $Y=756 $D=1
M64 82 43 45 VSS nmos_rvt L=2e-08 W=5.4e-08 nfin=2 $X=29228 $Y=756 $D=1
M65 VSS 44 82 VSS nmos_rvt L=2e-08 W=5.4e-08 nfin=2 $X=29444 $Y=756 $D=1
M66 VSS 45 n35 VSS nmos_rvt L=2e-08 W=5.4e-08 nfin=2 $X=30092 $Y=756 $D=1
M67 83 38 46 VSS nmos_rvt L=2e-08 W=5.4e-08 nfin=2 $X=30740 $Y=756 $D=1
M68 VSS 40 83 VSS nmos_rvt L=2e-08 W=5.4e-08 nfin=2 $X=30956 $Y=756 $D=1
M69 VSS 46 47 VSS nmos_rvt L=2e-08 W=5.4e-08 nfin=2 $X=31604 $Y=756 $D=1
M70 84 37 48 VSS nmos_rvt L=2e-08 W=5.4e-08 nfin=2 $X=32252 $Y=756 $D=1
M71 VSS 47 84 VSS nmos_rvt L=2e-08 W=5.4e-08 nfin=2 $X=32468 $Y=756 $D=1
M72 VSS 48 n39 VSS nmos_rvt L=2e-08 W=5.4e-08 nfin=2 $X=33116 $Y=756 $D=1
M73 VDD i0 3 VDD pmos_rvt L=2e-08 W=5.4e-08 nfin=2 $X=716 $Y=1836 $D=0
M74 3 i4 VDD VDD pmos_rvt L=2e-08 W=5.4e-08 nfin=2 $X=932 $Y=1836 $D=0
M75 VDD 3 8 VDD pmos_rvt L=2e-08 W=5.4e-08 nfin=2 $X=1580 $Y=1836 $D=0
M76 VDD i1 7 VDD pmos_rvt L=2e-08 W=5.4e-08 nfin=2 $X=2228 $Y=1836 $D=0
M77 VDD i5 6 VDD pmos_rvt L=2e-08 W=5.4e-08 nfin=2 $X=2876 $Y=1836 $D=0
M78 9 i1 51 VDD pmos_rvt L=2e-08 W=5.4e-08 nfin=2 $X=3524 $Y=1836 $D=0
M79 51 i5 9 VDD pmos_rvt L=2e-08 W=5.4e-08 nfin=2 $X=3740 $Y=1836 $D=0
M80 VDD 6 51 VDD pmos_rvt L=2e-08 W=5.4e-08 nfin=2 $X=3956 $Y=1836 $D=0
M81 51 7 VDD VDD pmos_rvt L=2e-08 W=5.4e-08 nfin=2 $X=4172 $Y=1836 $D=0
M82 VDD 8 10 VDD pmos_rvt L=2e-08 W=5.4e-08 nfin=2 $X=4820 $Y=1836 $D=0
M83 10 9 VDD VDD pmos_rvt L=2e-08 W=5.4e-08 nfin=2 $X=5036 $Y=1836 $D=0
M84 VDD 10 27 VDD pmos_rvt L=2e-08 W=5.4e-08 nfin=2 $X=5684 $Y=1836 $D=0
M85 VDD i2 13 VDD pmos_rvt L=2e-08 W=5.4e-08 nfin=2 $X=6332 $Y=1836 $D=0
M86 13 i6 VDD VDD pmos_rvt L=2e-08 W=5.4e-08 nfin=2 $X=6548 $Y=1836 $D=0
M87 VDD 13 18 VDD pmos_rvt L=2e-08 W=5.4e-08 nfin=2 $X=7196 $Y=1836 $D=0
M88 VDD i3 17 VDD pmos_rvt L=2e-08 W=5.4e-08 nfin=2 $X=7844 $Y=1836 $D=0
M89 VDD i7 16 VDD pmos_rvt L=2e-08 W=5.4e-08 nfin=2 $X=8492 $Y=1836 $D=0
M90 19 i3 52 VDD pmos_rvt L=2e-08 W=5.4e-08 nfin=2 $X=9140 $Y=1836 $D=0
M91 52 i7 19 VDD pmos_rvt L=2e-08 W=5.4e-08 nfin=2 $X=9356 $Y=1836 $D=0
M92 VDD 16 52 VDD pmos_rvt L=2e-08 W=5.4e-08 nfin=2 $X=9572 $Y=1836 $D=0
M93 52 17 VDD VDD pmos_rvt L=2e-08 W=5.4e-08 nfin=2 $X=9788 $Y=1836 $D=0
M94 VDD 18 20 VDD pmos_rvt L=2e-08 W=5.4e-08 nfin=2 $X=10436 $Y=1836 $D=0
M95 20 19 VDD VDD pmos_rvt L=2e-08 W=5.4e-08 nfin=2 $X=10652 $Y=1836 $D=0
M96 VDD 20 28 VDD pmos_rvt L=2e-08 W=5.4e-08 nfin=2 $X=11300 $Y=1836 $D=0
M97 21 8 53 VDD pmos_rvt L=2e-08 W=5.4e-08 nfin=2 $X=11948 $Y=1836 $D=0
M98 53 18 21 VDD pmos_rvt L=2e-08 W=5.4e-08 nfin=2 $X=12164 $Y=1836 $D=0
M99 VDD 13 53 VDD pmos_rvt L=2e-08 W=5.4e-08 nfin=2 $X=12380 $Y=1836 $D=0
M100 53 3 VDD VDD pmos_rvt L=2e-08 W=5.4e-08 nfin=2 $X=12596 $Y=1836 $D=0
M101 VDD 21 24 VDD pmos_rvt L=2e-08 W=5.4e-08 nfin=2 $X=13244 $Y=1836 $D=0
M102 VDD i8 23 VDD pmos_rvt L=2e-08 W=5.4e-08 nfin=2 $X=13892 $Y=1836 $D=0
M103 43 21 54 VDD pmos_rvt L=2e-08 W=5.4e-08 nfin=2 $X=14540 $Y=1836 $D=0
M104 54 i8 43 VDD pmos_rvt L=2e-08 W=5.4e-08 nfin=2 $X=14756 $Y=1836 $D=0
M105 VDD 23 54 VDD pmos_rvt L=2e-08 W=5.4e-08 nfin=2 $X=14972 $Y=1836 $D=0
M106 54 24 VDD VDD pmos_rvt L=2e-08 W=5.4e-08 nfin=2 $X=15188 $Y=1836 $D=0
M107 VDD 8 25 VDD pmos_rvt L=2e-08 W=5.4e-08 nfin=2 $X=15836 $Y=1836 $D=0
M108 25 18 VDD VDD pmos_rvt L=2e-08 W=5.4e-08 nfin=2 $X=16052 $Y=1836 $D=0
M109 VDD 21 26 VDD pmos_rvt L=2e-08 W=5.4e-08 nfin=2 $X=16700 $Y=1836 $D=0
M110 26 i8 VDD VDD pmos_rvt L=2e-08 W=5.4e-08 nfin=2 $X=16916 $Y=1836 $D=0
M111 VDD 25 37 VDD pmos_rvt L=2e-08 W=5.4e-08 nfin=2 $X=17564 $Y=1836 $D=0
M112 37 26 VDD VDD pmos_rvt L=2e-08 W=5.4e-08 nfin=2 $X=17780 $Y=1836 $D=0
M113 29 27 55 VDD pmos_rvt L=2e-08 W=5.4e-08 nfin=2 $X=18428 $Y=1836 $D=0
M114 55 28 29 VDD pmos_rvt L=2e-08 W=5.4e-08 nfin=2 $X=18644 $Y=1836 $D=0
M115 VDD 20 55 VDD pmos_rvt L=2e-08 W=5.4e-08 nfin=2 $X=18860 $Y=1836 $D=0
M116 55 10 VDD VDD pmos_rvt L=2e-08 W=5.4e-08 nfin=2 $X=19076 $Y=1836 $D=0
M117 VDD 29 32 VDD pmos_rvt L=2e-08 W=5.4e-08 nfin=2 $X=19724 $Y=1836 $D=0
M118 VDD i9 31 VDD pmos_rvt L=2e-08 W=5.4e-08 nfin=2 $X=20372 $Y=1836 $D=0
M119 36 29 56 VDD pmos_rvt L=2e-08 W=5.4e-08 nfin=2 $X=21020 $Y=1836 $D=0
M120 56 i9 36 VDD pmos_rvt L=2e-08 W=5.4e-08 nfin=2 $X=21236 $Y=1836 $D=0
M121 VDD 31 56 VDD pmos_rvt L=2e-08 W=5.4e-08 nfin=2 $X=21452 $Y=1836 $D=0
M122 56 32 VDD VDD pmos_rvt L=2e-08 W=5.4e-08 nfin=2 $X=21668 $Y=1836 $D=0
M123 VDD 27 33 VDD pmos_rvt L=2e-08 W=5.4e-08 nfin=2 $X=22316 $Y=1836 $D=0
M124 33 28 VDD VDD pmos_rvt L=2e-08 W=5.4e-08 nfin=2 $X=22532 $Y=1836 $D=0
M125 VDD 29 34 VDD pmos_rvt L=2e-08 W=5.4e-08 nfin=2 $X=23180 $Y=1836 $D=0
M126 34 i9 VDD VDD pmos_rvt L=2e-08 W=5.4e-08 nfin=2 $X=23396 $Y=1836 $D=0
M127 VDD 33 35 VDD pmos_rvt L=2e-08 W=5.4e-08 nfin=2 $X=24044 $Y=1836 $D=0
M128 35 34 VDD VDD pmos_rvt L=2e-08 W=5.4e-08 nfin=2 $X=24260 $Y=1836 $D=0
M129 VDD 35 40 VDD pmos_rvt L=2e-08 W=5.4e-08 nfin=2 $X=24908 $Y=1836 $D=0
M130 VDD 36 38 VDD pmos_rvt L=2e-08 W=5.4e-08 nfin=2 $X=25556 $Y=1836 $D=0
M131 85 37 39 VDD pmos_rvt L=2e-08 W=5.4e-08 nfin=2 $X=26204 $Y=1836 $D=0
M132 VDD 38 85 VDD pmos_rvt L=2e-08 W=5.4e-08 nfin=2 $X=26420 $Y=1836 $D=0
M133 VDD 39 41 VDD pmos_rvt L=2e-08 W=5.4e-08 nfin=2 $X=27068 $Y=1836 $D=0
M134 VDD 40 42 VDD pmos_rvt L=2e-08 W=5.4e-08 nfin=2 $X=27716 $Y=1836 $D=0
M135 42 41 VDD VDD pmos_rvt L=2e-08 W=5.4e-08 nfin=2 $X=27932 $Y=1836 $D=0
M136 VDD 42 44 VDD pmos_rvt L=2e-08 W=5.4e-08 nfin=2 $X=28580 $Y=1836 $D=0
M137 VDD 43 45 VDD pmos_rvt L=2e-08 W=5.4e-08 nfin=2 $X=29228 $Y=1836 $D=0
M138 45 44 VDD VDD pmos_rvt L=2e-08 W=5.4e-08 nfin=2 $X=29444 $Y=1836 $D=0
M139 VDD 45 n35 VDD pmos_rvt L=2e-08 W=5.4e-08 nfin=2 $X=30092 $Y=1836 $D=0
M140 VDD 38 46 VDD pmos_rvt L=2e-08 W=5.4e-08 nfin=2 $X=30740 $Y=1836 $D=0
M141 46 40 VDD VDD pmos_rvt L=2e-08 W=5.4e-08 nfin=2 $X=30956 $Y=1836 $D=0
M142 VDD 46 47 VDD pmos_rvt L=2e-08 W=5.4e-08 nfin=2 $X=31604 $Y=1836 $D=0
M143 VDD 37 48 VDD pmos_rvt L=2e-08 W=5.4e-08 nfin=2 $X=32252 $Y=1836 $D=0
M144 48 47 VDD VDD pmos_rvt L=2e-08 W=5.4e-08 nfin=2 $X=32468 $Y=1836 $D=0
M145 VDD 48 n39 VDD pmos_rvt L=2e-08 W=5.4e-08 nfin=2 $X=33116 $Y=1836 $D=0
.ENDS
***************************************
