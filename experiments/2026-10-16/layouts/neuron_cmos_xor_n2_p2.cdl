.SUBCKT neuron_cmos_xor_n2_p2 i0 i1 i2 i3 i4 i5 i6 i7 i8 i9 n35 n39 VDD VSS
M1 n0 i0 j1 VSS nmos_rvt L=20n W=54n nfin=2
M2 j1 i4 VSS VSS nmos_rvt L=20n W=54n nfin=2
M3 n0 i0 VDD VDD pmos_rvt L=20n W=54n nfin=2
M4 n0 i4 VDD VDD pmos_rvt L=20n W=54n nfin=2
M5 n1 n0 VSS VSS nmos_rvt L=20n W=54n nfin=2
M6 n1 n0 VDD VDD pmos_rvt L=20n W=54n nfin=2
M7 n2 i1 VSS VSS nmos_rvt L=20n W=54n nfin=2
M8 n2 i1 VDD VDD pmos_rvt L=20n W=54n nfin=2
M9 n3 i5 VSS VSS nmos_rvt L=20n W=54n nfin=2
M10 n3 i5 VDD VDD pmos_rvt L=20n W=54n nfin=2
M11 n4 i1 j3 VSS nmos_rvt L=20n W=54n nfin=2
M12 j3 i5 VSS VSS nmos_rvt L=20n W=54n nfin=2
M13 n4 n2 j5 VSS nmos_rvt L=20n W=54n nfin=2
M14 j5 n3 VSS VSS nmos_rvt L=20n W=54n nfin=2
M15 n4 i1 j7 VDD pmos_rvt L=20n W=54n nfin=2
M16 n4 i5 j7 VDD pmos_rvt L=20n W=54n nfin=2
M17 j7 n2 VDD VDD pmos_rvt L=20n W=54n nfin=2
M18 j7 n3 VDD VDD pmos_rvt L=20n W=54n nfin=2
M19 n5 n1 j9 VSS nmos_rvt L=20n W=54n nfin=2
M20 j9 n4 VSS VSS nmos_rvt L=20n W=54n nfin=2
M21 n5 n1 VDD VDD pmos_rvt L=20n W=54n nfin=2
M22 n5 n4 VDD VDD pmos_rvt L=20n W=54n nfin=2
M23 n6 n5 VSS VSS nmos_rvt L=20n W=54n nfin=2
M24 n6 n5 VDD VDD pmos_rvt L=20n W=54n nfin=2
M25 n7 i2 j11 VSS nmos_rvt L=20n W=54n nfin=2
M26 j11 i6 VSS VSS nmos_rvt L=20n W=54n nfin=2
M27 n7 i2 VDD VDD pmos_rvt L=20n W=54n nfin=2
M28 n7 i6 VDD VDD pmos_rvt L=20n W=54n nfin=2
M29 n8 n7 VSS VSS nmos_rvt L=20n W=54n nfin=2
M30 n8 n7 VDD VDD pmos_rvt L=20n W=54n nfin=2
M31 n9 i3 VSS VSS nmos_rvt L=20n W=54n nfin=2
M32 n9 i3 VDD VDD pmos_rvt L=20n W=54n nfin=2
M33 n10 i7 VSS VSS nmos_rvt L=20n W=54n nfin=2
M34 n10 i7 VDD VDD pmos_rvt L=20n W=54n nfin=2
M35 n11 i3 j13 VSS nmos_rvt L=20n W=54n nfin=2
M36 j13 i7 VSS VSS nmos_rvt L=20n W=54n nfin=2
M37 n11 n9 j15 VSS nmos_rvt L=20n W=54n nfin=2
M38 j15 n10 VSS VSS nmos_rvt L=20n W=54n nfin=2
M39 n11 i3 j17 VDD pmos_rvt L=20n W=54n nfin=2
M40 n11 i7 j17 VDD pmos_rvt L=20n W=54n nfin=2
M41 j17 n9 VDD VDD pmos_rvt L=20n W=54n nfin=2
M42 j17 n10 VDD VDD pmos_rvt L=20n W=54n nfin=2
M43 n12 n8 j19 VSS nmos_rvt L=20n W=54n nfin=2
M44 j19 n11 VSS VSS nmos_rvt L=20n W=54n nfin=2
M45 n12 n8 VDD VDD pmos_rvt L=20n W=54n nfin=2
M46 n12 n11 VDD VDD pmos_rvt L=20n W=54n nfin=2
M47 n13 n12 VSS VSS nmos_rvt L=20n W=54n nfin=2
M48 n13 n12 VDD VDD pmos_rvt L=20n W=54n nfin=2
M49 n14 n1 j21 VSS nmos_rvt L=20n W=54n nfin=2
M50 j21 n8 VSS VSS nmos_rvt L=20n W=54n nfin=2
M51 n14 n0 j23 VSS nmos_rvt L=20n W=54n nfin=2
M52 j23 n7 VSS VSS nmos_rvt L=20n W=54n nfin=2
M53 n14 n1 j25 VDD pmos_rvt L=20n W=54n nfin=2
M54 n14 n8 j25 VDD pmos_rvt L=20n W=54n nfin=2
M55 j25 n0 VDD VDD pmos_rvt L=20n W=54n nfin=2
M56 j25 n7 VDD VDD pmos_rvt L=20n W=54n nfin=2
M57 n15 n14 VSS VSS nmos_rvt L=20n W=54n nfin=2
M58 n15 n14 VDD VDD pmos_rvt L=20n W=54n nfin=2
M59 n16 i8 VSS VSS nmos_rvt L=20n W=54n nfin=2
M60 n16 i8 VDD VDD pmos_rvt L=20n W=54n nfin=2
M61 n17 n14 j27 VSS nmos_rvt L=20n W=54n nfin=2
M62 j27 i8 VSS VSS nmos_rvt L=20n W=54n nfin=2
M63 n17 n15 j29 VSS nmos_rvt L=20n W=54n nfin=2
M64 j29 n16 VSS VSS nmos_rvt L=20n W=54n nfin=2
M65 n17 n14 j31 VDD pmos_rvt L=20n W=54n nfin=2
M66 n17 i8 j31 VDD pmos_rvt L=20n W=54n nfin=2
M67 j31 n15 VDD VDD pmos_rvt L=20n W=54n nfin=2
M68 j31 n16 VDD VDD pmos_rvt L=20n W=54n nfin=2
M69 n18 n1 j33 VSS nmos_rvt L=20n W=54n nfin=2
M70 j33 n8 VSS VSS nmos_rvt L=20n W=54n nfin=2
M71 n18 n1 VDD VDD pmos_rvt L=20n W=54n nfin=2
M72 n18 n8 VDD VDD pmos_rvt L=20n W=54n nfin=2
M73 n19 n14 j35 VSS nmos_rvt L=20n W=54n nfin=2
M74 j35 i8 VSS VSS nmos_rvt L=20n W=54n nfin=2
M75 n19 n14 VDD VDD pmos_rvt L=20n W=54n nfin=2
M76 n19 i8 VDD VDD pmos_rvt L=20n W=54n nfin=2
M77 n20 n18 j37 VSS nmos_rvt L=20n W=54n nfin=2
M78 j37 n19 VSS VSS nmos_rvt L=20n W=54n nfin=2
M79 n20 n18 VDD VDD pmos_rvt L=20n W=54n nfin=2
M80 n20 n19 VDD VDD pmos_rvt L=20n W=54n nfin=2
M81 n21 n6 j39 VSS nmos_rvt L=20n W=54n nfin=2
M82 j39 n13 VSS VSS nmos_rvt L=20n W=54n nfin=2
M83 n21 n5 j41 VSS nmos_rvt L=20n W=54n nfin=2
M84 j41 n12 VSS VSS nmos_rvt L=20n W=54n nfin=2
M85 n21 n6 j43 VDD pmos_rvt L=20n W=54n nfin=2
M86 n21 n13 j43 VDD pmos_rvt L=20n W=54n nfin=2
M87 j43 n5 VDD VDD pmos_rvt L=20n W=54n nfin=2
M88 j43 n12 VDD VDD pmos_rvt L=20n W=54n nfin=2
M89 n22 n21 VSS VSS nmos_rvt L=20n W=54n nfin=2
M90 n22 n21 VDD VDD pmos_rvt L=20n W=54n nfin=2
M91 n23 i9 VSS VSS nmos_rvt L=20n W=54n nfin=2
M92 n23 i9 VDD VDD pmos_rvt L=20n W=54n nfin=2
M93 n24 n21 j45 VSS nmos_rvt L=20n W=54n nfin=2
M94 j45 i9 VSS VSS nmos_rvt L=20n W=54n nfin=2
M95 n24 n22 j47 VSS nmos_rvt L=20n W=54n nfin=2
M96 j47 n23 VSS VSS nmos_rvt L=20n W=54n nfin=2
M97 n24 n21 j49 VDD pmos_rvt L=20n W=54n nfin=2
M98 n24 i9 j49 VDD pmos_rvt L=20n W=54n nfin=2
M99 j49 n22 VDD VDD pmos_rvt L=20n W=54n nfin=2
M100 j49 n23 VDD VDD pmos_rvt L=20n W=54n nfin=2
M101 n25 n6 j51 VSS nmos_rvt L=20n W=54n nfin=2
M102 j51 n13 VSS VSS nmos_rvt L=20n W=54n nfin=2
M103 n25 n6 VDD VDD pmos_rvt L=20n W=54n nfin=2
M104 n25 n13 VDD VDD pmos_rvt L=20n W=54n nfin=2
M105 n26 n21 j53 VSS nmos_rvt L=20n W=54n nfin=2
M106 j53 i9 VSS VSS nmos_rvt L=20n W=54n nfin=2
M107 n26 n21 VDD VDD pmos_rvt L=20n W=54n nfin=2
M108 n26 i9 VDD VDD pmos_rvt L=20n W=54n nfin=2
M109 n27 n25 j55 VSS nmos_rvt L=20n W=54n nfin=2
M110 j55 n26 VSS VSS nmos_rvt L=20n W=54n nfin=2
M111 n27 n25 VDD VDD pmos_rvt L=20n W=54n nfin=2
M112 n27 n26 VDD VDD pmos_rvt L=20n W=54n nfin=2
M113 n28 n27 VSS VSS nmos_rvt L=20n W=54n nfin=2
M114 n28 n27 VDD VDD pmos_rvt L=20n W=54n nfin=2
M115 n29 n24 VSS VSS nmos_rvt L=20n W=54n nfin=2
M116 n29 n24 VDD VDD pmos_rvt L=20n W=54n nfin=2
M117 n30 n20 VSS VSS nmos_rvt L=20n W=54n nfin=2
M118 n30 n29 VSS VSS nmos_rvt L=20n W=54n nfin=2
M119 n30 n20 j57 VDD pmos_rvt L=20n W=54n nfin=2
M120 j57 n29 VDD VDD pmos_rvt L=20n W=54n nfin=2
M121 n31 n30 VSS VSS nmos_rvt L=20n W=54n nfin=2
M122 n31 n30 VDD VDD pmos_rvt L=20n W=54n nfin=2
M123 n32 n28 j59 VSS nmos_rvt L=20n W=54n nfin=2
M124 j59 n31 VSS VSS nmos_rvt L=20n W=54n nfin=2
M125 n32 n28 VDD VDD pmos_rvt L=20n W=54n nfin=2
M126 n32 n31 VDD VDD pmos_rvt L=20n W=54n nfin=2
M127 n33 n32 VSS VSS nmos_rvt L=20n W=54n nfin=2
M128 n33 n32 VDD VDD pmos_rvt L=20n W=54n nfin=2
M129 n34 n17 j61 VSS nmos_rvt L=20n W=54n nfin=2
M130 j61 n33 VSS VSS nmos_rvt L=20n W=54n nfin=2
M131 n34 n17 VDD VDD pmos_rvt L=20n W=54n nfin=2
M132 n34 n33 VDD VDD pmos_rvt L=20n W=54n nfin=2
M133 n35 n34 VSS VSS nmos_rvt L=20n W=54n nfin=2
M134 n35 n34 VDD VDD pmos_rvt L=20n W=54n nfin=2
M135 n36 n29 j63 VSS nmos_rvt L=20n W=54n nfin=2
M136 j63 n28 VSS VSS nmos_rvt L=20n W=54n nfin=2
M137 n36 n29 VDD VDD pmos_rvt L=20n W=54n nfin=2
M138 n36 n28 VDD VDD pmos_rvt L=20n W=54n nfin=2
M139 n37 n36 VSS VSS nmos_rvt L=20n W=54n nfin=2
M140 n37 n36 VDD VDD pmos_rvt L=20n W=54n nfin=2
M141 n38 n20 j65 VSS nmos_rvt L=20n W=54n nfin=2
M142 j65 n37 VSS VSS nmos_rvt L=20n W=54n nfin=2
M143 n38 n20 VDD VDD pmos_rvt L=20n W=54n nfin=2
M144 n38 n37 VDD VDD pmos_rvt L=20n W=54n nfin=2
M145 n39 n38 VSS VSS nmos_rvt L=20n W=54n nfin=2
M146 n39 n38 VDD VDD pmos_rvt L=20n W=54n nfin=2
.ENDS
