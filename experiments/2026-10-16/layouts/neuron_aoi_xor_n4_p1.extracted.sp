* SPICE NETLIST
***************************************

.SUBCKT neuron_aoi_xor_n4_p1 i0 i4 i1 i5 i2 i6 i3 i7 i8 i9 VSS VDD n26 n27
** N=194 EP=14 IP=0 FDC=122
M0 48 i0 3 VSS nmos_rvt L=2e-08 W=1.08e-07 nfin=4 $X=716 $Y=756 $D=1
M1 VSS i4 48 VSS nmos_rvt L=2e-08 W=1.08e-07 nfin=4 $X=932 $Y=756 $D=1
M2 VSS 3 15 VSS nmos_rvt L=2e-08 W=1.08e-07 nfin=4 $X=1580 $Y=756 $D=1
M3 49 i1 6 VSS nmos_rvt L=2e-08 W=1.08e-07 nfin=4 $X=2228 $Y=756 $D=1
M4 VSS i5 49 VSS nmos_rvt L=2e-08 W=1.08e-07 nfin=4 $X=2444 $Y=756 $D=1
M5 7 i1 39 VSS nmos_rvt L=2e-08 W=1.08e-07 nfin=4 $X=3092 $Y=756 $D=1
M6 39 i5 7 VSS nmos_rvt L=2e-08 W=1.08e-07 nfin=4 $X=3308 $Y=756 $D=1
M7 VSS 6 39 VSS nmos_rvt L=2e-08 W=1.08e-07 nfin=4 $X=3524 $Y=756 $D=1
M8 VSS 3 23 VSS nmos_rvt L=2e-08 W=1.08e-07 nfin=4 $X=4172 $Y=756 $D=1
M9 23 7 VSS VSS nmos_rvt L=2e-08 W=1.08e-07 nfin=4 $X=4388 $Y=756 $D=1
M10 50 i2 10 VSS nmos_rvt L=2e-08 W=1.08e-07 nfin=4 $X=5036 $Y=756 $D=1
M11 VSS i6 50 VSS nmos_rvt L=2e-08 W=1.08e-07 nfin=4 $X=5252 $Y=756 $D=1
M12 VSS 10 16 VSS nmos_rvt L=2e-08 W=1.08e-07 nfin=4 $X=5900 $Y=756 $D=1
M13 51 i3 13 VSS nmos_rvt L=2e-08 W=1.08e-07 nfin=4 $X=6548 $Y=756 $D=1
M14 VSS i7 51 VSS nmos_rvt L=2e-08 W=1.08e-07 nfin=4 $X=6764 $Y=756 $D=1
M15 14 i3 40 VSS nmos_rvt L=2e-08 W=1.08e-07 nfin=4 $X=7412 $Y=756 $D=1
M16 40 i7 14 VSS nmos_rvt L=2e-08 W=1.08e-07 nfin=4 $X=7628 $Y=756 $D=1
M17 VSS 13 40 VSS nmos_rvt L=2e-08 W=1.08e-07 nfin=4 $X=7844 $Y=756 $D=1
M18 VSS 10 24 VSS nmos_rvt L=2e-08 W=1.08e-07 nfin=4 $X=8492 $Y=756 $D=1
M19 24 14 VSS VSS nmos_rvt L=2e-08 W=1.08e-07 nfin=4 $X=8708 $Y=756 $D=1
M20 VSS 15 17 VSS nmos_rvt L=2e-08 W=1.08e-07 nfin=4 $X=9356 $Y=756 $D=1
M21 17 16 VSS VSS nmos_rvt L=2e-08 W=1.08e-07 nfin=4 $X=9572 $Y=756 $D=1
M22 52 15 18 VSS nmos_rvt L=2e-08 W=1.08e-07 nfin=4 $X=10220 $Y=756 $D=1
M23 VSS 16 52 VSS nmos_rvt L=2e-08 W=1.08e-07 nfin=4 $X=10436 $Y=756 $D=1
M24 18 17 VSS VSS nmos_rvt L=2e-08 W=1.08e-07 nfin=4 $X=10652 $Y=756 $D=1
M25 VSS 18 20 VSS nmos_rvt L=2e-08 W=1.08e-07 nfin=4 $X=11300 $Y=756 $D=1
M26 20 i8 VSS VSS nmos_rvt L=2e-08 W=1.08e-07 nfin=4 $X=11516 $Y=756 $D=1
M27 53 18 32 VSS nmos_rvt L=2e-08 W=1.08e-07 nfin=4 $X=12164 $Y=756 $D=1
M28 VSS i8 53 VSS nmos_rvt L=2e-08 W=1.08e-07 nfin=4 $X=12380 $Y=756 $D=1
M29 32 20 VSS VSS nmos_rvt L=2e-08 W=1.08e-07 nfin=4 $X=12596 $Y=756 $D=1
M30 54 15 21 VSS nmos_rvt L=2e-08 W=1.08e-07 nfin=4 $X=13244 $Y=756 $D=1
M31 VSS 16 54 VSS nmos_rvt L=2e-08 W=1.08e-07 nfin=4 $X=13460 $Y=756 $D=1
M32 55 18 22 VSS nmos_rvt L=2e-08 W=1.08e-07 nfin=4 $X=14108 $Y=756 $D=1
M33 VSS i8 55 VSS nmos_rvt L=2e-08 W=1.08e-07 nfin=4 $X=14324 $Y=756 $D=1
M34 56 21 31 VSS nmos_rvt L=2e-08 W=1.08e-07 nfin=4 $X=14972 $Y=756 $D=1
M35 VSS 22 56 VSS nmos_rvt L=2e-08 W=1.08e-07 nfin=4 $X=15188 $Y=756 $D=1
M36 VSS 23 25 VSS nmos_rvt L=2e-08 W=1.08e-07 nfin=4 $X=15836 $Y=756 $D=1
M37 25 24 VSS VSS nmos_rvt L=2e-08 W=1.08e-07 nfin=4 $X=16052 $Y=756 $D=1
M38 57 23 26 VSS nmos_rvt L=2e-08 W=1.08e-07 nfin=4 $X=16700 $Y=756 $D=1
M39 VSS 24 57 VSS nmos_rvt L=2e-08 W=1.08e-07 nfin=4 $X=16916 $Y=756 $D=1
M40 26 25 VSS VSS nmos_rvt L=2e-08 W=1.08e-07 nfin=4 $X=17132 $Y=756 $D=1
M41 VSS 26 28 VSS nmos_rvt L=2e-08 W=1.08e-07 nfin=4 $X=17780 $Y=756 $D=1
M42 28 i9 VSS VSS nmos_rvt L=2e-08 W=1.08e-07 nfin=4 $X=17996 $Y=756 $D=1
M43 58 26 34 VSS nmos_rvt L=2e-08 W=1.08e-07 nfin=4 $X=18644 $Y=756 $D=1
M44 VSS i9 58 VSS nmos_rvt L=2e-08 W=1.08e-07 nfin=4 $X=18860 $Y=756 $D=1
M45 34 28 VSS VSS nmos_rvt L=2e-08 W=1.08e-07 nfin=4 $X=19076 $Y=756 $D=1
M46 59 23 29 VSS nmos_rvt L=2e-08 W=1.08e-07 nfin=4 $X=19724 $Y=756 $D=1
M47 VSS 24 59 VSS nmos_rvt L=2e-08 W=1.08e-07 nfin=4 $X=19940 $Y=756 $D=1
M48 60 26 30 VSS nmos_rvt L=2e-08 W=1.08e-07 nfin=4 $X=20588 $Y=756 $D=1
M49 VSS i9 60 VSS nmos_rvt L=2e-08 W=1.08e-07 nfin=4 $X=20804 $Y=756 $D=1
M50 61 29 36 VSS nmos_rvt L=2e-08 W=1.08e-07 nfin=4 $X=21452 $Y=756 $D=1
M51 VSS 30 61 VSS nmos_rvt L=2e-08 W=1.08e-07 nfin=4 $X=21668 $Y=756 $D=1
M52 VSS 31 33 VSS nmos_rvt L=2e-08 W=1.08e-07 nfin=4 $X=22316 $Y=756 $D=1
M53 VSS 32 35 VSS nmos_rvt L=2e-08 W=1.08e-07 nfin=4 $X=22964 $Y=756 $D=1
M54 62 33 n26 VSS nmos_rvt L=2e-08 W=1.08e-07 nfin=4 $X=23612 $Y=756 $D=1
M55 VSS 34 62 VSS nmos_rvt L=2e-08 W=1.08e-07 nfin=4 $X=23828 $Y=756 $D=1
M56 n26 35 VSS VSS nmos_rvt L=2e-08 W=1.08e-07 nfin=4 $X=24044 $Y=756 $D=1
M57 VSS 36 n26 VSS nmos_rvt L=2e-08 W=1.08e-07 nfin=4 $X=24260 $Y=756 $D=1
M58 VSS 33 n27 VSS nmos_rvt L=2e-08 W=1.08e-07 nfin=4 $X=24908 $Y=756 $D=1
M59 n27 34 VSS VSS nmos_rvt L=2e-08 W=1.08e-07 nfin=4 $X=25124 $Y=756 $D=1
M60 VSS 36 n27 VSS nmos_rvt L=2e-08 W=1.08e-07 nfin=4 $X=25340 $Y=756 $D=1
M61 VDD i0 3 VDD pmos_rvt L=2e-08 W=2.7e-08 nfin=1 $X=716 $Y=2052 $D=0
M62 3 i4 VDD VDD pmos_rvt L=2e-08 W=2.7e-08 nfin=1 $X=932 $Y=2052 $D=0
M63 VDD 3 15 VDD pmos_rvt L=2e-08 W=2.7e-08 nfin=1 $X=1580 $Y=2052 $D=0
M64 VDD i1 6 VDD pmos_rvt L=2e-08 W=2.7e-08 nfin=1 $X=2228 $Y=2052 $D=0
M65 6 i5 VDD VDD pmos_rvt L=2e-08 W=2.7e-08 nfin=1 $X=2444 $Y=2052 $D=0
M66 63 i1 7 VDD pmos_rvt L=2e-08 W=2.7e-08 nfin=1 $X=3092 $Y=2052 $D=0
M67 VDD i5 63 VDD pmos_rvt L=2e-08 W=2.7e-08 nfin=1 $X=3308 $Y=2052 $D=0
M68 7 6 VDD VDD pmos_rvt L=2e-08 W=2.7e-08 nfin=1 $X=3524 $Y=2052 $D=0
M69 64 3 23 VDD pmos_rvt L=2e-08 W=2.7e-08 nfin=1 $X=4172 $Y=2052 $D=0
M70 VDD 7 64 VDD pmos_rvt L=2e-08 W=2.7e-08 nfin=1 $X=4388 $Y=2052 $D=0
M71 VDD i2 10 VDD pmos_rvt L=2e-08 W=2.7e-08 nfin=1 $X=5036 $Y=2052 $D=0
M72 10 i6 VDD VDD pmos_rvt L=2e-08 W=2.7e-08 nfin=1 $X=5252 $Y=2052 $D=0
M73 VDD 10 16 VDD pmos_rvt L=2e-08 W=2.7e-08 nfin=1 $X=5900 $Y=2052 $D=0
M74 VDD i3 13 VDD pmos_rvt L=2e-08 W=2.7e-08 nfin=1 $X=6548 $Y=2052 $D=0
M75 13 i7 VDD VDD pmos_rvt L=2e-08 W=2.7e-08 nfin=1 $X=6764 $Y=2052 $D=0
M76 65 i3 14 VDD pmos_rvt L=2e-08 W=2.7e-08 nfin=1 $X=7412 $Y=2052 $D=0
M77 VDD i7 65 VDD pmos_rvt L=2e-08 W=2.7e-08 nfin=1 $X=7628 $Y=2052 $D=0
M78 14 13 VDD VDD pmos_rvt L=2e-08 W=2.7e-08 nfin=1 $X=7844 $Y=2052 $D=0
M79 66 10 24 VDD pmos_rvt L=2e-08 W=2.7e-08 nfin=1 $X=8492 $Y=2052 $D=0
M80 VDD 14 66 VDD pmos_rvt L=2e-08 W=2.7e-08 nfin=1 $X=8708 $Y=2052 $D=0
M81 67 15 17 VDD pmos_rvt L=2e-08 W=2.7e-08 nfin=1 $X=9356 $Y=2052 $D=0
M82 VDD 16 67 VDD pmos_rvt L=2e-08 W=2.7e-08 nfin=1 $X=9572 $Y=2052 $D=0
M83 18 15 41 VDD pmos_rvt L=2e-08 W=2.7e-08 nfin=1 $X=10220 $Y=2052 $D=0
M84 41 16 18 VDD pmos_rvt L=2e-08 W=2.7e-08 nfin=1 $X=10436 $Y=2052 $D=0
M85 VDD 17 41 VDD pmos_rvt L=2e-08 W=2.7e-08 nfin=1 $X=10652 $Y=2052 $D=0
M86 68 18 20 VDD pmos_rvt L=2e-08 W=2.7e-08 nfin=1 $X=11300 $Y=2052 $D=0
M87 VDD i8 68 VDD pmos_rvt L=2e-08 W=2.7e-08 nfin=1 $X=11516 $Y=2052 $D=0
M88 32 18 42 VDD pmos_rvt L=2e-08 W=2.7e-08 nfin=1 $X=12164 $Y=2052 $D=0
M89 42 i8 32 VDD pmos_rvt L=2e-08 W=2.7e-08 nfin=1 $X=12380 $Y=2052 $D=0
M90 VDD 20 42 VDD pmos_rvt L=2e-08 W=2.7e-08 nfin=1 $X=12596 $Y=2052 $D=0
M91 VDD 15 21 VDD pmos_rvt L=2e-08 W=2.7e-08 nfin=1 $X=13244 $Y=2052 $D=0
M92 21 16 VDD VDD pmos_rvt L=2e-08 W=2.7e-08 nfin=1 $X=13460 $Y=2052 $D=0
M93 VDD 18 22 VDD pmos_rvt L=2e-08 W=2.7e-08 nfin=1 $X=14108 $Y=2052 $D=0
M94 22 i8 VDD VDD pmos_rvt L=2e-08 W=2.7e-08 nfin=1 $X=14324 $Y=2052 $D=0
M95 VDD 21 31 VDD pmos_rvt L=2e-08 W=2.7e-08 nfin=1 $X=14972 $Y=2052 $D=0
M96 31 22 VDD VDD pmos_rvt L=2e-08 W=2.7e-08 nfin=1 $X=15188 $Y=2052 $D=0
M97 69 23 25 VDD pmos_rvt L=2e-08 W=2.7e-08 nfin=1 $X=15836 $Y=2052 $D=0
M98 VDD 24 69 VDD pmos_rvt L=2e-08 W=2.7e-08 nfin=1 $X=16052 $Y=2052 $D=0
M99 26 23 43 VDD pmos_rvt L=2e-08 W=2.7e-08 nfin=1 $X=16700 $Y=2052 $D=0
M100 43 24 26 VDD pmos_rvt L=2e-08 W=2.7e-08 nfin=1 $X=16916 $Y=2052 $D=0
M101 VDD 25 43 VDD pmos_rvt L=2e-08 W=2.7e-08 nfin=1 $X=17132 $Y=2052 $D=0
M102 70 26 28 VDD pmos_rvt L=2e-08 W=2.7e-08 nfin=1 $X=17780 $Y=2052 $D=0
M103 VDD i9 70 VDD pmos_rvt L=2e-08 W=2.7e-08 nfin=1 $X=17996 $Y=2052 $D=0
M104 34 26 44 VDD pmos_rvt L=2e-08 W=2.7e-08 nfin=1 $X=18644 $Y=2052 $D=0
M105 44 i9 34 VDD pmos_rvt L=2e-08 W=2.7e-08 nfin=1 $X=18860 $Y=2052 $D=0
M106 VDD 28 44 VDD pmos_rvt L=2e-08 W=2.7e-08 nfin=1 $X=19076 $Y=2052 $D=0
M107 VDD 23 29 VDD pmos_rvt L=2e-08 W=2.7e-08 nfin=1 $X=19724 $Y=2052 $D=0
M108 29 24 VDD VDD pmos_rvt L=2e-08 W=2.7e-08 nfin=1 $X=19940 $Y=2052 $D=0
M109 VDD 26 30 VDD pmos_rvt L=2e-08 W=2.7e-08 nfin=1 $X=20588 $Y=2052 $D=0
M110 30 i9 VDD VDD pmos_rvt L=2e-08 W=2.7e-08 nfin=1 $X=20804 $Y=2052 $D=0
M111 VDD 29 36 VDD pmos_rvt L=2e-08 W=2.7e-08 nfin=1 $X=21452 $Y=2052 $D=0
M112 36 30 VDD VDD pmos_rvt L=2e-08 W=2.7e-08 nfin=1 $X=21668 $Y=2052 $D=0
M113 VDD 31 33 VDD pmos_rvt L=2e-08 W=2.7e-08 nfin=1 $X=22316 $Y=2052 $D=0
M114 VDD 32 35 VDD pmos_rvt L=2e-08 W=2.7e-08 nfin=1 $X=22964 $Y=2052 $D=0
M115 n26 33 46 VDD pmos_rvt L=2e-08 W=2.7e-08 nfin=1 $X=23612 $Y=2052 $D=0
M116 46 34 n26 VDD pmos_rvt L=2e-08 W=2.7e-08 nfin=1 $X=23828 $Y=2052 $D=0
M117 71 35 46 VDD pmos_rvt L=2e-08 W=2.7e-08 nfin=1 $X=24044 $Y=2052 $D=0
M118 VDD 36 71 VDD pmos_rvt L=2e-08 W=2.7e-08 nfin=1 $X=24260 $Y=2052 $D=0
M119 72 33 n27 VDD pmos_rvt L=2e-08 W=2.7e-08 nfin=1 $X=24908 $Y=2052 $D=0
M120 73 34 72 VDD pmos_rvt L=2e-08 W=2.7e-08 nfin=1 $X=25124 $Y=2052 $D=0
M121 VDD 36 73 VDD pmos_rvt L=2e-08 W=2.7e-08 nfin=1 $X=25340 $Y=2052 $D=0
.ENDS
***************************************
