.SUBCKT neuron_aoi_xor_n3_p3 i0 i1 i2 i3 i4 i5 i6 i7 i8 i9 n26 n27 VDD VSS
M1 n0 i0 j1 VSS nmos_rvt L=20n W=81n nfin=3
M2 j1 i4 VSS VSS nmos_rvt L=20n W=81n nfin=3
M3 n0 i0 VDD VDD pmos_rvt L=20n W=81n nfin=3
M4 n0 i4 VDD VDD pmos_rvt L=20n W=81n nfin=3
M5 n1 n0 VSS VSS nmos_rvt L=20n W=81n nfin=3
M6 n1 n0 VDD VDD pmos_rvt L=20n W=81n nfin=3
M7 n2 i1 j3 VSS nmos_rvt L=20n W=81n nfin=3
M8 j3 i5 VSS VSS nmos_rvt L=20n W=81n nfin=3
M9 n2 i1 VDD VDD pmos_rvt L=20n W=81n nfin=3
M10 n2 i5 VDD VDD pmos_rvt L=20n W=81n nfin=3
M11 n3 i1 j5 VSS nmos_rvt L=20n W=81n nfin=3
M12 n3 i5 j5 VSS nmos_rvt L=20n W=81n nfin=3
M13 j5 n2 VSS VSS nmos_rvt L=20n W=81n nfin=3
M14 n3 i1 j7 VDD pmos_rvt L=20n W=81n nfin=3
M15 j7 i5 VDD VDD pmos_rvt L=20n W=81n nfin=3
M16 n3 n2 VDD VDD pmos_rvt L=20n W=81n nfin=3
M17 n4 n0 VSS VSS nmos_rvt L=20n W=81n nfin=3
M18 n4 n3 VSS VSS nmos_rvt L=20n W=81n nfin=3
M19 n4 n0 j9 VDD pmos_rvt L=20n W=81n nfin=3
M20 j9 n3 VDD VDD pmos_rvt L=20n W=81n nfin=3
M21 n5 i2 j11 VSS nmos_rvt L=20n W=81n nfin=3
M22 j11 i6 VSS VSS nmos_rvt L=20n W=81n nfin=3
M23 n5 i2 VDD VDD pmos_rvt L=20n W=81n nfin=3
M24 n5 i6 VDD VDD pmos_rvt L=20n W=81n nfin=3
M25 n6 n5 VSS VSS nmos_rvt L=20n W=81n nfin=3
M26 n6 n5 VDD VDD pmos_rvt L=20n W=81n nfin=3
M27 n7 i3 j13 VSS nmos_rvt L=20n W=81n nfin=3
M28 j13 i7 VSS VSS nmos_rvt L=20n W=81n nfin=3
M29 n7 i3 VDD VDD pmos_rvt L=20n W=81n nfin=3
M30 n7 i7 VDD VDD pmos_rvt L=20n W=81n nfin=3
M31 n8 i3 j15 VSS nmos_rvt L=20n W=81n nfin=3
M32 n8 i7 j15 VSS nmos_rvt L=20n W=81n nfin=3
M33 j15 n7 VSS VSS nmos_rvt L=20n W=81n nfin=3
M34 n8 i3 j17 VDD pmos_rvt L=20n W=81n nfin=3
M35 j17 i7 VDD VDD pmos_rvt L=20n W=81n nfin=3
M36 n8 n7 VDD VDD pmos_rvt L=20n W=81n nfin=3
M37 n9 n5 VSS VSS nmos_rvt L=20n W=81n nfin=3
M38 n9 n8 VSS VSS nmos_rvt L=20n W=81n nfin=3
M39 n9 n5 j19 VDD pmos_rvt L=20n W=81n nfin=3
M40 j19 n8 VDD VDD pmos_rvt L=20n W=81n nfin=3
M41 n10 n1 VSS VSS nmos_rvt L=20n W=81n nfin=3
M42 n10 n6 VSS VSS nmos_rvt L=20n W=81n nfin=3
M43 n10 n1 j21 VDD pmos_rvt L=20n W=81n nfin=3
M44 j21 n6 VDD VDD pmos_rvt L=20n W=81n nfin=3
M45 n11 n1 j23 VSS nmos_rvt L=20n W=81n nfin=3
M46 j23 n6 VSS VSS nmos_rvt L=20n W=81n nfin=3
M47 n11 n10 VSS VSS nmos_rvt L=20n W=81n nfin=3
M48 n11 n1 j25 VDD pmos_rvt L=20n W=81n nfin=3
M49 n11 n6 j25 VDD pmos_rvt L=20n W=81n nfin=3
M50 j25 n10 VDD VDD pmos_rvt L=20n W=81n nfin=3
M51 n12 n11 VSS VSS nmos_rvt L=20n W=81n nfin=3
M52 n12 i8 VSS VSS nmos_rvt L=20n W=81n nfin=3
M53 n12 n11 j27 VDD pmos_rvt L=20n W=81n nfin=3
M54 j27 i8 VDD VDD pmos_rvt L=20n W=81n nfin=3
M55 n13 n11 j29 VSS nmos_rvt L=20n W=81n nfin=3
M56 j29 i8 VSS VSS nmos_rvt L=20n W=81n nfin=3
M57 n13 n12 VSS VSS nmos_rvt L=20n W=81n nfin=3
M58 n13 n11 j31 VDD pmos_rvt L=20n W=81n nfin=3
M59 n13 i8 j31 VDD pmos_rvt L=20n W=81n nfin=3
M60 j31 n12 VDD VDD pmos_rvt L=20n W=81n nfin=3
M61 n14 n1 j33 VSS nmos_rvt L=20n W=81n nfin=3
M62 j33 n6 VSS VSS nmos_rvt L=20n W=81n nfin=3
M63 n14 n1 VDD VDD pmos_rvt L=20n W=81n nfin=3
M64 n14 n6 VDD VDD pmos_rvt L=20n W=81n nfin=3
M65 n15 n11 j35 VSS nmos_rvt L=20n W=81n nfin=3
M66 j35 i8 VSS VSS nmos_rvt L=20n W=81n nfin=3
M67 n15 n11 VDD VDD pmos_rvt L=20n W=81n nfin=3
M68 n15 i8 VDD VDD pmos_rvt L=20n W=81n nfin=3
M69 n16 n14 j37 VSS nmos_rvt L=20n W=81n nfin=3
M70 j37 n15 VSS VSS nmos_rvt L=20n W=81n nfin=3
M71 n16 n14 VDD VDD pmos_rvt L=20n W=81n nfin=3
M72 n16 n15 VDD VDD pmos_rvt L=20n W=81n nfin=3
M73 n17 n4 VSS VSS nmos_rvt L=20n W=81n nfin=3
M74 n17 n9 VSS VSS nmos_rvt L=20n W=81n nfin=3
M75 n17 n4 j39 VDD pmos_rvt L=20n W=81n nfin=3
M76 j39 n9 VDD VDD pmos_rvt L=20n W=81n nfin=3
M77 n18 n4 j41 VSS nmos_rvt L=20n W=81n nfin=3
M78 j41 n9 VSS VSS nmos_rvt L=20n W=81n nfin=3
M79 n18 n17 VSS VSS nmos_rvt L=20n W=81n nfin=3
M80 n18 n4 j43 VDD pmos_rvt L=20n W=81n nfin=3
M81 n18 n9 j43 VDD pmos_rvt L=20n W=81n nfin=3
M82 j43 n17 VDD VDD pmos_rvt L=20n W=81n nfin=3
M83 n19 n18 VSS VSS nmos_rvt L=20n W=81n nfin=3
M84 n19 i9 VSS VSS nmos_rvt L=20n W=81n nfin=3
M85 n19 n18 j45 VDD pmos_rvt L=20n W=81n nfin=3
M86 j45 i9 VDD VDD pmos_rvt L=20n W=81n nfin=3
M87 n20 n18 j47 VSS nmos_rvt L=20n W=81n nfin=3
M88 j47 i9 VSS VSS nmos_rvt L=20n W=81n nfin=3
M89 n20 n19 VSS VSS nmos_rvt L=20n W=81n nfin=3
M90 n20 n18 j49 VDD pmos_rvt L=20n W=81n nfin=3
M91 n20 i9 j49 VDD pmos_rvt L=20n W=81n nfin=3
M92 j49 n19 VDD VDD pmos_rvt L=20n W=81n nfin=3
M93 n21 n4 j51 VSS nmos_rvt L=20n W=81n nfin=3
M94 j51 n9 VSS VSS nmos_rvt L=20n W=81n nfin=3
M95 n21 n4 VDD VDD pmos_rvt L=20n W=81n nfin=3
M96 n21 n9 VDD VDD pmos_rvt L=20n W=81n nfin=3
M97 n22 n18 j53 VSS nmos_rvt L=20n W=81n nfin=3
M98 j53 i9 VSS VSS nmos_rvt L=20n W=81n nfin=3
M99 n22 n18 VDD VDD pmos_rvt L=20n W=81n nfin=3
M100 n22 i9 VDD VDD pmos_rvt L=20n W=81n nfin=3
M101 n23 n21 j55 VSS nmos_rvt L=20n W=81n nfin=3
M102 j55 n22 VSS VSS nmos_rvt L=20n W=81n nfin=3
M103 n23 n21 VDD VDD pmos_rvt L=20n W=81n nfin=3
M104 n23 n22 VDD VDD pmos_rvt L=20n W=81n nfin=3
M105 n24 n16 VSS VSS nmos_rvt L=20n W=81n nfin=3
M106 n24 n16 VDD VDD pmos_rvt L=20n W=81n nfin=3
M107 n25 n13 VSS VSS nmos_rvt L=20n W=81n nfin=3
M108 n25 n13 VDD VDD pmos_rvt L=20n W=81n nfin=3
M109 n26 n24 j57 VSS nmos_rvt L=20n W=81n nfin=3
M110 j57 n20 VSS VSS nmos_rvt L=20n W=81n nfin=3
M111 n26 n25 VSS VSS nmos_rvt L=20n W=81n nfin=3
M112 n26 n23 VSS VSS nmos_rvt L=20n W=81n nfin=3
M113 n26 n24 j59 VDD pmos_rvt L=20n W=81n nfin=3
M114 n26 n20 j59 VDD pmos_rvt L=20n W=81n nfin=3
M115 j59 n25 j60 VDD pmos_rvt L=20n W=81n nfin=3
M116 j60 n23 VDD VDD pmos_rvt L=20n W=81n nfin=3
M117 n27 n24 VSS VSS nmos_rvt L=20n W=81n nfin=3
M118 n27 n20 VSS VSS nmos_rvt L=20n W=81n nfin=3
M119 n27 n23 VSS VSS nmos_rvt L=20n W=81n nfin=3
M120 n27 n24 j62 VDD pmos_rvt L=20n W=81n nfin=3
M121 j62 n20 j63 VDD pmos_rvt L=20n W=81n nfin=3
M122 j63 n23 VDD VDD pmos_rvt L=20n W=81n nfin=3
.ENDS
